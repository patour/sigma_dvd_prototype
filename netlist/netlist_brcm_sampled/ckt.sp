.partition_info 6 6
.die_area 0 0 19152000 16628040
.parameter VDD_VAR 0.76
vVDD_VAR vVDD_VAR  0  VDD_VAR
.include ./tile_0_0.ckt
.include ./tile_0_1.ckt
.include ./tile_0_2.ckt
.include ./tile_0_3.ckt
.include ./tile_0_4.ckt
.include ./tile_0_5.ckt
.include ./tile_1_0.ckt
.include ./tile_1_1.ckt
.include ./tile_1_2.ckt
.include ./tile_1_3.ckt
.include ./tile_1_4.ckt
.include ./tile_1_5.ckt
.include ./tile_2_0.ckt
.include ./tile_2_1.ckt
.include ./tile_2_2.ckt
.include ./tile_2_3.ckt
.include ./tile_2_4.ckt
.include ./tile_2_5.ckt
.include ./tile_3_0.ckt
.include ./tile_3_1.ckt
.include ./tile_3_2.ckt
.include ./tile_3_3.ckt
.include ./tile_3_4.ckt
.include ./tile_3_5.ckt
.include ./tile_4_0.ckt
.include ./tile_4_1.ckt
.include ./tile_4_2.ckt
.include ./tile_4_3.ckt
.include ./tile_4_4.ckt
.include ./tile_4_5.ckt
.include ./tile_5_0.ckt
.include ./tile_5_1.ckt
.include ./tile_5_2.ckt
.include ./tile_5_3.ckt
.include ./tile_5_4.ckt
.include ./tile_5_5.ckt
.include ./package.ckt
.include ./instanceModels_0_0.sp
.include ./instanceModels_0_1.sp
.include ./instanceModels_0_2.sp
.include ./instanceModels_0_3.sp
.include ./instanceModels_0_4.sp
.include ./instanceModels_0_5.sp
.include ./instanceModels_1_0.sp
.include ./instanceModels_1_1.sp
.include ./instanceModels_1_2.sp
.include ./instanceModels_1_3.sp
.include ./instanceModels_1_4.sp
.include ./instanceModels_1_5.sp
.include ./instanceModels_2_0.sp
.include ./instanceModels_2_1.sp
.include ./instanceModels_2_2.sp
.include ./instanceModels_2_3.sp
.include ./instanceModels_2_4.sp
.include ./instanceModels_2_5.sp
.include ./instanceModels_3_0.sp
.include ./instanceModels_3_1.sp
.include ./instanceModels_3_2.sp
.include ./instanceModels_3_3.sp
.include ./instanceModels_3_4.sp
.include ./instanceModels_3_5.sp
.include ./instanceModels_4_0.sp
.include ./instanceModels_4_1.sp
.include ./instanceModels_4_2.sp
.include ./instanceModels_4_3.sp
.include ./instanceModels_4_4.sp
.include ./instanceModels_4_5.sp
.include ./instanceModels_5_0.sp
.include ./instanceModels_5_1.sp
.include ./instanceModels_5_2.sp
.include ./instanceModels_5_3.sp
.include ./instanceModels_5_4.sp
.include ./instanceModels_5_5.sp
