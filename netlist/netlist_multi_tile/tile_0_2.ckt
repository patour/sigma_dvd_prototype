* Tile 0_2 netlist
* Multi-layer routing with R, C elements
* Includes ground caps, coupling caps, and decaps

* ========== Layer M1 ==========
* Horizontal resistors (R=8 Ohm)
R_h_M1_0_0 0_2000_M1 100_2000_M1 8
R_h_M1_1_0 100_2000_M1 200_2000_M1 8
R_h_M1_2_0 200_2000_M1 300_2000_M1 8
R_h_M1_3_0 300_2000_M1 400_2000_M1 8
R_h_M1_4_0 400_2000_M1 500_2000_M1 8
R_h_M1_5_0 500_2000_M1 600_2000_M1 8
R_h_M1_6_0 600_2000_M1 700_2000_M1 8
R_h_M1_7_0 700_2000_M1 800_2000_M1 8
R_h_M1_8_0 800_2000_M1 900_2000_M1 8
R_h_M1_0_1 0_2100_M1 100_2100_M1 8
R_h_M1_1_1 100_2100_M1 200_2100_M1 8
R_h_M1_2_1 200_2100_M1 300_2100_M1 8
R_h_M1_3_1 300_2100_M1 400_2100_M1 8
R_h_M1_4_1 400_2100_M1 500_2100_M1 8
R_h_M1_5_1 500_2100_M1 600_2100_M1 8
R_h_M1_6_1 600_2100_M1 700_2100_M1 8
R_h_M1_7_1 700_2100_M1 800_2100_M1 8
R_h_M1_8_1 800_2100_M1 900_2100_M1 8
R_h_M1_0_2 0_2200_M1 100_2200_M1 8
R_h_M1_1_2 100_2200_M1 200_2200_M1 8
R_h_M1_2_2 200_2200_M1 300_2200_M1 8
R_h_M1_3_2 300_2200_M1 400_2200_M1 8
R_h_M1_4_2 400_2200_M1 500_2200_M1 8
R_h_M1_5_2 500_2200_M1 600_2200_M1 8
R_h_M1_6_2 600_2200_M1 700_2200_M1 8
R_h_M1_7_2 700_2200_M1 800_2200_M1 8
R_h_M1_8_2 800_2200_M1 900_2200_M1 8
R_h_M1_0_3 0_2300_M1 100_2300_M1 8
R_h_M1_1_3 100_2300_M1 200_2300_M1 8
R_h_M1_2_3 200_2300_M1 300_2300_M1 8
R_h_M1_3_3 300_2300_M1 400_2300_M1 8
R_h_M1_4_3 400_2300_M1 500_2300_M1 8
R_h_M1_5_3 500_2300_M1 600_2300_M1 8
R_h_M1_6_3 600_2300_M1 700_2300_M1 8
R_h_M1_7_3 700_2300_M1 800_2300_M1 8
R_h_M1_8_3 800_2300_M1 900_2300_M1 8
R_h_M1_0_4 0_2400_M1 100_2400_M1 8
R_h_M1_1_4 100_2400_M1 200_2400_M1 8
R_h_M1_2_4 200_2400_M1 300_2400_M1 8
R_h_M1_3_4 300_2400_M1 400_2400_M1 8
R_h_M1_4_4 400_2400_M1 500_2400_M1 8
R_h_M1_5_4 500_2400_M1 600_2400_M1 8
R_h_M1_6_4 600_2400_M1 700_2400_M1 8
R_h_M1_7_4 700_2400_M1 800_2400_M1 8
R_h_M1_8_4 800_2400_M1 900_2400_M1 8
R_h_M1_0_5 0_2500_M1 100_2500_M1 8
R_h_M1_1_5 100_2500_M1 200_2500_M1 8
R_h_M1_2_5 200_2500_M1 300_2500_M1 8
R_h_M1_3_5 300_2500_M1 400_2500_M1 8
R_h_M1_4_5 400_2500_M1 500_2500_M1 8
R_h_M1_5_5 500_2500_M1 600_2500_M1 8
R_h_M1_6_5 600_2500_M1 700_2500_M1 8
R_h_M1_7_5 700_2500_M1 800_2500_M1 8
R_h_M1_8_5 800_2500_M1 900_2500_M1 8
R_h_M1_0_6 0_2600_M1 100_2600_M1 8
R_h_M1_1_6 100_2600_M1 200_2600_M1 8
R_h_M1_2_6 200_2600_M1 300_2600_M1 8
R_h_M1_3_6 300_2600_M1 400_2600_M1 8
R_h_M1_4_6 400_2600_M1 500_2600_M1 8
R_h_M1_5_6 500_2600_M1 600_2600_M1 8
R_h_M1_6_6 600_2600_M1 700_2600_M1 8
R_h_M1_7_6 700_2600_M1 800_2600_M1 8
R_h_M1_8_6 800_2600_M1 900_2600_M1 8
R_h_M1_0_7 0_2700_M1 100_2700_M1 8
R_h_M1_1_7 100_2700_M1 200_2700_M1 8
R_h_M1_2_7 200_2700_M1 300_2700_M1 8
R_h_M1_3_7 300_2700_M1 400_2700_M1 8
R_h_M1_4_7 400_2700_M1 500_2700_M1 8
R_h_M1_5_7 500_2700_M1 600_2700_M1 8
R_h_M1_6_7 600_2700_M1 700_2700_M1 8
R_h_M1_7_7 700_2700_M1 800_2700_M1 8
R_h_M1_8_7 800_2700_M1 900_2700_M1 8
R_h_M1_0_8 0_2800_M1 100_2800_M1 8
R_h_M1_1_8 100_2800_M1 200_2800_M1 8
R_h_M1_2_8 200_2800_M1 300_2800_M1 8
R_h_M1_3_8 300_2800_M1 400_2800_M1 8
R_h_M1_4_8 400_2800_M1 500_2800_M1 8
R_h_M1_5_8 500_2800_M1 600_2800_M1 8
R_h_M1_6_8 600_2800_M1 700_2800_M1 8
R_h_M1_7_8 700_2800_M1 800_2800_M1 8
R_h_M1_8_8 800_2800_M1 900_2800_M1 8
R_h_M1_0_9 0_2900_M1 100_2900_M1 8
R_h_M1_1_9 100_2900_M1 200_2900_M1 8
R_h_M1_2_9 200_2900_M1 300_2900_M1 8
R_h_M1_3_9 300_2900_M1 400_2900_M1 8
R_h_M1_4_9 400_2900_M1 500_2900_M1 8
R_h_M1_5_9 500_2900_M1 600_2900_M1 8
R_h_M1_6_9 600_2900_M1 700_2900_M1 8
R_h_M1_7_9 700_2900_M1 800_2900_M1 8
R_h_M1_8_9 800_2900_M1 900_2900_M1 8
* Vertical resistors (R=10 Ohm)
R_v_M1_0_0 0_2000_M1 0_2100_M1 10
R_v_M1_1_0 100_2000_M1 100_2100_M1 10
R_v_M1_2_0 200_2000_M1 200_2100_M1 10
R_v_M1_3_0 300_2000_M1 300_2100_M1 10
R_v_M1_4_0 400_2000_M1 400_2100_M1 10
R_v_M1_5_0 500_2000_M1 500_2100_M1 10
R_v_M1_6_0 600_2000_M1 600_2100_M1 10
R_v_M1_7_0 700_2000_M1 700_2100_M1 10
R_v_M1_8_0 800_2000_M1 800_2100_M1 10
R_v_M1_9_0 900_2000_M1 900_2100_M1 10
R_v_M1_0_1 0_2100_M1 0_2200_M1 10
R_v_M1_1_1 100_2100_M1 100_2200_M1 10
R_v_M1_2_1 200_2100_M1 200_2200_M1 10
R_v_M1_3_1 300_2100_M1 300_2200_M1 10
R_v_M1_4_1 400_2100_M1 400_2200_M1 10
R_v_M1_5_1 500_2100_M1 500_2200_M1 10
R_v_M1_6_1 600_2100_M1 600_2200_M1 10
R_v_M1_7_1 700_2100_M1 700_2200_M1 10
R_v_M1_8_1 800_2100_M1 800_2200_M1 10
R_v_M1_9_1 900_2100_M1 900_2200_M1 10
R_v_M1_0_2 0_2200_M1 0_2300_M1 10
R_v_M1_1_2 100_2200_M1 100_2300_M1 10
R_v_M1_2_2 200_2200_M1 200_2300_M1 10
R_v_M1_3_2 300_2200_M1 300_2300_M1 10
R_v_M1_4_2 400_2200_M1 400_2300_M1 10
R_v_M1_5_2 500_2200_M1 500_2300_M1 10
R_v_M1_6_2 600_2200_M1 600_2300_M1 10
R_v_M1_7_2 700_2200_M1 700_2300_M1 10
R_v_M1_8_2 800_2200_M1 800_2300_M1 10
R_v_M1_9_2 900_2200_M1 900_2300_M1 10
R_v_M1_0_3 0_2300_M1 0_2400_M1 10
R_v_M1_1_3 100_2300_M1 100_2400_M1 10
R_v_M1_2_3 200_2300_M1 200_2400_M1 10
R_v_M1_3_3 300_2300_M1 300_2400_M1 10
R_v_M1_4_3 400_2300_M1 400_2400_M1 10
R_v_M1_5_3 500_2300_M1 500_2400_M1 10
R_v_M1_6_3 600_2300_M1 600_2400_M1 10
R_v_M1_7_3 700_2300_M1 700_2400_M1 10
R_v_M1_8_3 800_2300_M1 800_2400_M1 10
R_v_M1_9_3 900_2300_M1 900_2400_M1 10
R_v_M1_0_4 0_2400_M1 0_2500_M1 10
R_v_M1_1_4 100_2400_M1 100_2500_M1 10
R_v_M1_2_4 200_2400_M1 200_2500_M1 10
R_v_M1_3_4 300_2400_M1 300_2500_M1 10
R_v_M1_4_4 400_2400_M1 400_2500_M1 10
R_v_M1_5_4 500_2400_M1 500_2500_M1 10
R_v_M1_6_4 600_2400_M1 600_2500_M1 10
R_v_M1_7_4 700_2400_M1 700_2500_M1 10
R_v_M1_8_4 800_2400_M1 800_2500_M1 10
R_v_M1_9_4 900_2400_M1 900_2500_M1 10
R_v_M1_0_5 0_2500_M1 0_2600_M1 10
R_v_M1_1_5 100_2500_M1 100_2600_M1 10
R_v_M1_2_5 200_2500_M1 200_2600_M1 10
R_v_M1_3_5 300_2500_M1 300_2600_M1 10
R_v_M1_4_5 400_2500_M1 400_2600_M1 10
R_v_M1_5_5 500_2500_M1 500_2600_M1 10
R_v_M1_6_5 600_2500_M1 600_2600_M1 10
R_v_M1_7_5 700_2500_M1 700_2600_M1 10
R_v_M1_8_5 800_2500_M1 800_2600_M1 10
R_v_M1_9_5 900_2500_M1 900_2600_M1 10
R_v_M1_0_6 0_2600_M1 0_2700_M1 10
R_v_M1_1_6 100_2600_M1 100_2700_M1 10
R_v_M1_2_6 200_2600_M1 200_2700_M1 10
R_v_M1_3_6 300_2600_M1 300_2700_M1 10
R_v_M1_4_6 400_2600_M1 400_2700_M1 10
R_v_M1_5_6 500_2600_M1 500_2700_M1 10
R_v_M1_6_6 600_2600_M1 600_2700_M1 10
R_v_M1_7_6 700_2600_M1 700_2700_M1 10
R_v_M1_8_6 800_2600_M1 800_2700_M1 10
R_v_M1_9_6 900_2600_M1 900_2700_M1 10
R_v_M1_0_7 0_2700_M1 0_2800_M1 10
R_v_M1_1_7 100_2700_M1 100_2800_M1 10
R_v_M1_2_7 200_2700_M1 200_2800_M1 10
R_v_M1_3_7 300_2700_M1 300_2800_M1 10
R_v_M1_4_7 400_2700_M1 400_2800_M1 10
R_v_M1_5_7 500_2700_M1 500_2800_M1 10
R_v_M1_6_7 600_2700_M1 600_2800_M1 10
R_v_M1_7_7 700_2700_M1 700_2800_M1 10
R_v_M1_8_7 800_2700_M1 800_2800_M1 10
R_v_M1_9_7 900_2700_M1 900_2800_M1 10
R_v_M1_0_8 0_2800_M1 0_2900_M1 10
R_v_M1_1_8 100_2800_M1 100_2900_M1 10
R_v_M1_2_8 200_2800_M1 200_2900_M1 10
R_v_M1_3_8 300_2800_M1 300_2900_M1 10
R_v_M1_4_8 400_2800_M1 400_2900_M1 10
R_v_M1_5_8 500_2800_M1 500_2900_M1 10
R_v_M1_6_8 600_2800_M1 600_2900_M1 10
R_v_M1_7_8 700_2800_M1 700_2900_M1 10
R_v_M1_8_8 800_2800_M1 800_2900_M1 10
R_v_M1_9_8 900_2800_M1 900_2900_M1 10
* Ground capacitors (C=5.0 fF)
C_g_M1_0_0 0_2000_M1 0 5e-15
C_g_M1_1_0 100_2000_M1 0 5e-15
C_g_M1_2_0 200_2000_M1 0 5e-15
C_g_M1_3_0 300_2000_M1 0 5e-15
C_g_M1_4_0 400_2000_M1 0 5e-15
C_g_M1_5_0 500_2000_M1 0 5e-15
C_g_M1_6_0 600_2000_M1 0 5e-15
C_g_M1_7_0 700_2000_M1 0 5e-15
C_g_M1_8_0 800_2000_M1 0 5e-15
C_g_M1_9_0 900_2000_M1 0 5e-15
C_g_M1_0_1 0_2100_M1 0 5e-15
C_g_M1_1_1 100_2100_M1 0 5e-15
C_g_M1_2_1 200_2100_M1 0 5e-15
C_g_M1_3_1 300_2100_M1 0 5e-15
C_g_M1_4_1 400_2100_M1 0 5e-15
C_g_M1_5_1 500_2100_M1 0 5e-15
C_g_M1_6_1 600_2100_M1 0 5e-15
C_g_M1_7_1 700_2100_M1 0 5e-15
C_g_M1_8_1 800_2100_M1 0 5e-15
C_g_M1_9_1 900_2100_M1 0 5e-15
C_g_M1_0_2 0_2200_M1 0 5e-15
C_g_M1_1_2 100_2200_M1 0 5e-15
C_g_M1_2_2 200_2200_M1 0 5e-15
C_g_M1_3_2 300_2200_M1 0 5e-15
C_g_M1_4_2 400_2200_M1 0 5e-15
C_g_M1_5_2 500_2200_M1 0 5e-15
C_g_M1_6_2 600_2200_M1 0 5e-15
C_g_M1_7_2 700_2200_M1 0 5e-15
C_g_M1_8_2 800_2200_M1 0 5e-15
C_g_M1_9_2 900_2200_M1 0 5e-15
C_g_M1_0_3 0_2300_M1 0 5e-15
C_g_M1_1_3 100_2300_M1 0 5e-15
C_g_M1_2_3 200_2300_M1 0 5e-15
C_g_M1_3_3 300_2300_M1 0 5e-15
C_g_M1_4_3 400_2300_M1 0 5e-15
C_g_M1_5_3 500_2300_M1 0 5e-15
C_g_M1_6_3 600_2300_M1 0 5e-15
C_g_M1_7_3 700_2300_M1 0 5e-15
C_g_M1_8_3 800_2300_M1 0 5e-15
C_g_M1_9_3 900_2300_M1 0 5e-15
C_g_M1_0_4 0_2400_M1 0 5e-15
C_g_M1_1_4 100_2400_M1 0 5e-15
C_g_M1_2_4 200_2400_M1 0 5e-15
C_g_M1_3_4 300_2400_M1 0 5e-15
C_g_M1_4_4 400_2400_M1 0 5e-15
C_g_M1_5_4 500_2400_M1 0 5e-15
C_g_M1_6_4 600_2400_M1 0 5e-15
C_g_M1_7_4 700_2400_M1 0 5e-15
C_g_M1_8_4 800_2400_M1 0 5e-15
C_g_M1_9_4 900_2400_M1 0 5e-15
C_g_M1_0_5 0_2500_M1 0 5e-15
C_g_M1_1_5 100_2500_M1 0 5e-15
C_g_M1_2_5 200_2500_M1 0 5e-15
C_g_M1_3_5 300_2500_M1 0 5e-15
C_g_M1_4_5 400_2500_M1 0 5e-15
C_g_M1_5_5 500_2500_M1 0 5e-15
C_g_M1_6_5 600_2500_M1 0 5e-15
C_g_M1_7_5 700_2500_M1 0 5e-15
C_g_M1_8_5 800_2500_M1 0 5e-15
C_g_M1_9_5 900_2500_M1 0 5e-15
C_g_M1_0_6 0_2600_M1 0 5e-15
C_g_M1_1_6 100_2600_M1 0 5e-15
C_g_M1_2_6 200_2600_M1 0 5e-15
C_g_M1_3_6 300_2600_M1 0 5e-15
C_g_M1_4_6 400_2600_M1 0 5e-15
C_g_M1_5_6 500_2600_M1 0 5e-15
C_g_M1_6_6 600_2600_M1 0 5e-15
C_g_M1_7_6 700_2600_M1 0 5e-15
C_g_M1_8_6 800_2600_M1 0 5e-15
C_g_M1_9_6 900_2600_M1 0 5e-15
C_g_M1_0_7 0_2700_M1 0 5e-15
C_g_M1_1_7 100_2700_M1 0 5e-15
C_g_M1_2_7 200_2700_M1 0 5e-15
C_g_M1_3_7 300_2700_M1 0 5e-15
C_g_M1_4_7 400_2700_M1 0 5e-15
C_g_M1_5_7 500_2700_M1 0 5e-15
C_g_M1_6_7 600_2700_M1 0 5e-15
C_g_M1_7_7 700_2700_M1 0 5e-15
C_g_M1_8_7 800_2700_M1 0 5e-15
C_g_M1_9_7 900_2700_M1 0 5e-15
C_g_M1_0_8 0_2800_M1 0 5e-15
C_g_M1_1_8 100_2800_M1 0 5e-15
C_g_M1_2_8 200_2800_M1 0 5e-15
C_g_M1_3_8 300_2800_M1 0 5e-15
C_g_M1_4_8 400_2800_M1 0 5e-15
C_g_M1_5_8 500_2800_M1 0 5e-15
C_g_M1_6_8 600_2800_M1 0 5e-15
C_g_M1_7_8 700_2800_M1 0 5e-15
C_g_M1_8_8 800_2800_M1 0 5e-15
C_g_M1_9_8 900_2800_M1 0 5e-15
C_g_M1_0_9 0_2900_M1 0 5e-15
C_g_M1_1_9 100_2900_M1 0 5e-15
C_g_M1_2_9 200_2900_M1 0 5e-15
C_g_M1_3_9 300_2900_M1 0 5e-15
C_g_M1_4_9 400_2900_M1 0 5e-15
C_g_M1_5_9 500_2900_M1 0 5e-15
C_g_M1_6_9 600_2900_M1 0 5e-15
C_g_M1_7_9 700_2900_M1 0 5e-15
C_g_M1_8_9 800_2900_M1 0 5e-15
C_g_M1_9_9 900_2900_M1 0 5e-15
* Coupling capacitors (C=1.0 fF)
C_coup_M1_0_0 0_2000_M1 100_2000_M1 1e-15
C_coup_M1_2_0 200_2000_M1 300_2000_M1 1e-15
C_coup_M1_4_0 400_2000_M1 500_2000_M1 1e-15
C_coup_M1_6_0 600_2000_M1 700_2000_M1 1e-15
C_coup_M1_8_0 800_2000_M1 900_2000_M1 1e-15
C_coup_M1_0_1 0_2100_M1 100_2100_M1 1e-15
C_coup_M1_2_1 200_2100_M1 300_2100_M1 1e-15
C_coup_M1_4_1 400_2100_M1 500_2100_M1 1e-15
C_coup_M1_6_1 600_2100_M1 700_2100_M1 1e-15
C_coup_M1_8_1 800_2100_M1 900_2100_M1 1e-15
C_coup_M1_0_2 0_2200_M1 100_2200_M1 1e-15
C_coup_M1_2_2 200_2200_M1 300_2200_M1 1e-15
C_coup_M1_4_2 400_2200_M1 500_2200_M1 1e-15
C_coup_M1_6_2 600_2200_M1 700_2200_M1 1e-15
C_coup_M1_8_2 800_2200_M1 900_2200_M1 1e-15
C_coup_M1_0_3 0_2300_M1 100_2300_M1 1e-15
C_coup_M1_2_3 200_2300_M1 300_2300_M1 1e-15
C_coup_M1_4_3 400_2300_M1 500_2300_M1 1e-15
C_coup_M1_6_3 600_2300_M1 700_2300_M1 1e-15
C_coup_M1_8_3 800_2300_M1 900_2300_M1 1e-15
C_coup_M1_0_4 0_2400_M1 100_2400_M1 1e-15
C_coup_M1_2_4 200_2400_M1 300_2400_M1 1e-15
C_coup_M1_4_4 400_2400_M1 500_2400_M1 1e-15
C_coup_M1_6_4 600_2400_M1 700_2400_M1 1e-15
C_coup_M1_8_4 800_2400_M1 900_2400_M1 1e-15
C_coup_M1_0_5 0_2500_M1 100_2500_M1 1e-15
C_coup_M1_2_5 200_2500_M1 300_2500_M1 1e-15
C_coup_M1_4_5 400_2500_M1 500_2500_M1 1e-15
C_coup_M1_6_5 600_2500_M1 700_2500_M1 1e-15
C_coup_M1_8_5 800_2500_M1 900_2500_M1 1e-15
C_coup_M1_0_6 0_2600_M1 100_2600_M1 1e-15
C_coup_M1_2_6 200_2600_M1 300_2600_M1 1e-15
C_coup_M1_4_6 400_2600_M1 500_2600_M1 1e-15
C_coup_M1_6_6 600_2600_M1 700_2600_M1 1e-15
C_coup_M1_8_6 800_2600_M1 900_2600_M1 1e-15
C_coup_M1_0_7 0_2700_M1 100_2700_M1 1e-15
C_coup_M1_2_7 200_2700_M1 300_2700_M1 1e-15
C_coup_M1_4_7 400_2700_M1 500_2700_M1 1e-15
C_coup_M1_6_7 600_2700_M1 700_2700_M1 1e-15
C_coup_M1_8_7 800_2700_M1 900_2700_M1 1e-15
C_coup_M1_0_8 0_2800_M1 100_2800_M1 1e-15
C_coup_M1_2_8 200_2800_M1 300_2800_M1 1e-15
C_coup_M1_4_8 400_2800_M1 500_2800_M1 1e-15
C_coup_M1_6_8 600_2800_M1 700_2800_M1 1e-15
C_coup_M1_8_8 800_2800_M1 900_2800_M1 1e-15
C_coup_M1_0_9 0_2900_M1 100_2900_M1 1e-15
C_coup_M1_2_9 200_2900_M1 300_2900_M1 1e-15
C_coup_M1_4_9 400_2900_M1 500_2900_M1 1e-15
C_coup_M1_6_9 600_2900_M1 700_2900_M1 1e-15
C_coup_M1_8_9 800_2900_M1 900_2900_M1 1e-15

* ========== Layer M2 ==========
* Horizontal resistors (R=5 Ohm)
R_h_M2_0_0 0_2000_M2 100_2000_M2 5
R_h_M2_1_0 100_2000_M2 200_2000_M2 5
R_h_M2_2_0 200_2000_M2 300_2000_M2 5
R_h_M2_3_0 300_2000_M2 400_2000_M2 5
R_h_M2_4_0 400_2000_M2 500_2000_M2 5
R_h_M2_5_0 500_2000_M2 600_2000_M2 5
R_h_M2_6_0 600_2000_M2 700_2000_M2 5
R_h_M2_7_0 700_2000_M2 800_2000_M2 5
R_h_M2_8_0 800_2000_M2 900_2000_M2 5
R_h_M2_0_1 0_2100_M2 100_2100_M2 5
R_h_M2_1_1 100_2100_M2 200_2100_M2 5
R_h_M2_2_1 200_2100_M2 300_2100_M2 5
R_h_M2_3_1 300_2100_M2 400_2100_M2 5
R_h_M2_4_1 400_2100_M2 500_2100_M2 5
R_h_M2_5_1 500_2100_M2 600_2100_M2 5
R_h_M2_6_1 600_2100_M2 700_2100_M2 5
R_h_M2_7_1 700_2100_M2 800_2100_M2 5
R_h_M2_8_1 800_2100_M2 900_2100_M2 5
R_h_M2_0_2 0_2200_M2 100_2200_M2 5
R_h_M2_1_2 100_2200_M2 200_2200_M2 5
R_h_M2_2_2 200_2200_M2 300_2200_M2 5
R_h_M2_3_2 300_2200_M2 400_2200_M2 5
R_h_M2_4_2 400_2200_M2 500_2200_M2 5
R_h_M2_5_2 500_2200_M2 600_2200_M2 5
R_h_M2_6_2 600_2200_M2 700_2200_M2 5
R_h_M2_7_2 700_2200_M2 800_2200_M2 5
R_h_M2_8_2 800_2200_M2 900_2200_M2 5
R_h_M2_0_3 0_2300_M2 100_2300_M2 5
R_h_M2_1_3 100_2300_M2 200_2300_M2 5
R_h_M2_2_3 200_2300_M2 300_2300_M2 5
R_h_M2_3_3 300_2300_M2 400_2300_M2 5
R_h_M2_4_3 400_2300_M2 500_2300_M2 5
R_h_M2_5_3 500_2300_M2 600_2300_M2 5
R_h_M2_6_3 600_2300_M2 700_2300_M2 5
R_h_M2_7_3 700_2300_M2 800_2300_M2 5
R_h_M2_8_3 800_2300_M2 900_2300_M2 5
R_h_M2_0_4 0_2400_M2 100_2400_M2 5
R_h_M2_1_4 100_2400_M2 200_2400_M2 5
R_h_M2_2_4 200_2400_M2 300_2400_M2 5
R_h_M2_3_4 300_2400_M2 400_2400_M2 5
R_h_M2_4_4 400_2400_M2 500_2400_M2 5
R_h_M2_5_4 500_2400_M2 600_2400_M2 5
R_h_M2_6_4 600_2400_M2 700_2400_M2 5
R_h_M2_7_4 700_2400_M2 800_2400_M2 5
R_h_M2_8_4 800_2400_M2 900_2400_M2 5
R_h_M2_0_5 0_2500_M2 100_2500_M2 5
R_h_M2_1_5 100_2500_M2 200_2500_M2 5
R_h_M2_2_5 200_2500_M2 300_2500_M2 5
R_h_M2_3_5 300_2500_M2 400_2500_M2 5
R_h_M2_4_5 400_2500_M2 500_2500_M2 5
R_h_M2_5_5 500_2500_M2 600_2500_M2 5
R_h_M2_6_5 600_2500_M2 700_2500_M2 5
R_h_M2_7_5 700_2500_M2 800_2500_M2 5
R_h_M2_8_5 800_2500_M2 900_2500_M2 5
R_h_M2_0_6 0_2600_M2 100_2600_M2 5
R_h_M2_1_6 100_2600_M2 200_2600_M2 5
R_h_M2_2_6 200_2600_M2 300_2600_M2 5
R_h_M2_3_6 300_2600_M2 400_2600_M2 5
R_h_M2_4_6 400_2600_M2 500_2600_M2 5
R_h_M2_5_6 500_2600_M2 600_2600_M2 5
R_h_M2_6_6 600_2600_M2 700_2600_M2 5
R_h_M2_7_6 700_2600_M2 800_2600_M2 5
R_h_M2_8_6 800_2600_M2 900_2600_M2 5
R_h_M2_0_7 0_2700_M2 100_2700_M2 5
R_h_M2_1_7 100_2700_M2 200_2700_M2 5
R_h_M2_2_7 200_2700_M2 300_2700_M2 5
R_h_M2_3_7 300_2700_M2 400_2700_M2 5
R_h_M2_4_7 400_2700_M2 500_2700_M2 5
R_h_M2_5_7 500_2700_M2 600_2700_M2 5
R_h_M2_6_7 600_2700_M2 700_2700_M2 5
R_h_M2_7_7 700_2700_M2 800_2700_M2 5
R_h_M2_8_7 800_2700_M2 900_2700_M2 5
R_h_M2_0_8 0_2800_M2 100_2800_M2 5
R_h_M2_1_8 100_2800_M2 200_2800_M2 5
R_h_M2_2_8 200_2800_M2 300_2800_M2 5
R_h_M2_3_8 300_2800_M2 400_2800_M2 5
R_h_M2_4_8 400_2800_M2 500_2800_M2 5
R_h_M2_5_8 500_2800_M2 600_2800_M2 5
R_h_M2_6_8 600_2800_M2 700_2800_M2 5
R_h_M2_7_8 700_2800_M2 800_2800_M2 5
R_h_M2_8_8 800_2800_M2 900_2800_M2 5
R_h_M2_0_9 0_2900_M2 100_2900_M2 5
R_h_M2_1_9 100_2900_M2 200_2900_M2 5
R_h_M2_2_9 200_2900_M2 300_2900_M2 5
R_h_M2_3_9 300_2900_M2 400_2900_M2 5
R_h_M2_4_9 400_2900_M2 500_2900_M2 5
R_h_M2_5_9 500_2900_M2 600_2900_M2 5
R_h_M2_6_9 600_2900_M2 700_2900_M2 5
R_h_M2_7_9 700_2900_M2 800_2900_M2 5
R_h_M2_8_9 800_2900_M2 900_2900_M2 5
* Vertical resistors (R=6 Ohm)
R_v_M2_0_0 0_2000_M2 0_2100_M2 6
R_v_M2_1_0 100_2000_M2 100_2100_M2 6
R_v_M2_2_0 200_2000_M2 200_2100_M2 6
R_v_M2_3_0 300_2000_M2 300_2100_M2 6
R_v_M2_4_0 400_2000_M2 400_2100_M2 6
R_v_M2_5_0 500_2000_M2 500_2100_M2 6
R_v_M2_6_0 600_2000_M2 600_2100_M2 6
R_v_M2_7_0 700_2000_M2 700_2100_M2 6
R_v_M2_8_0 800_2000_M2 800_2100_M2 6
R_v_M2_9_0 900_2000_M2 900_2100_M2 6
R_v_M2_0_1 0_2100_M2 0_2200_M2 6
R_v_M2_1_1 100_2100_M2 100_2200_M2 6
R_v_M2_2_1 200_2100_M2 200_2200_M2 6
R_v_M2_3_1 300_2100_M2 300_2200_M2 6
R_v_M2_4_1 400_2100_M2 400_2200_M2 6
R_v_M2_5_1 500_2100_M2 500_2200_M2 6
R_v_M2_6_1 600_2100_M2 600_2200_M2 6
R_v_M2_7_1 700_2100_M2 700_2200_M2 6
R_v_M2_8_1 800_2100_M2 800_2200_M2 6
R_v_M2_9_1 900_2100_M2 900_2200_M2 6
R_v_M2_0_2 0_2200_M2 0_2300_M2 6
R_v_M2_1_2 100_2200_M2 100_2300_M2 6
R_v_M2_2_2 200_2200_M2 200_2300_M2 6
R_v_M2_3_2 300_2200_M2 300_2300_M2 6
R_v_M2_4_2 400_2200_M2 400_2300_M2 6
R_v_M2_5_2 500_2200_M2 500_2300_M2 6
R_v_M2_6_2 600_2200_M2 600_2300_M2 6
R_v_M2_7_2 700_2200_M2 700_2300_M2 6
R_v_M2_8_2 800_2200_M2 800_2300_M2 6
R_v_M2_9_2 900_2200_M2 900_2300_M2 6
R_v_M2_0_3 0_2300_M2 0_2400_M2 6
R_v_M2_1_3 100_2300_M2 100_2400_M2 6
R_v_M2_2_3 200_2300_M2 200_2400_M2 6
R_v_M2_3_3 300_2300_M2 300_2400_M2 6
R_v_M2_4_3 400_2300_M2 400_2400_M2 6
R_v_M2_5_3 500_2300_M2 500_2400_M2 6
R_v_M2_6_3 600_2300_M2 600_2400_M2 6
R_v_M2_7_3 700_2300_M2 700_2400_M2 6
R_v_M2_8_3 800_2300_M2 800_2400_M2 6
R_v_M2_9_3 900_2300_M2 900_2400_M2 6
R_v_M2_0_4 0_2400_M2 0_2500_M2 6
R_v_M2_1_4 100_2400_M2 100_2500_M2 6
R_v_M2_2_4 200_2400_M2 200_2500_M2 6
R_v_M2_3_4 300_2400_M2 300_2500_M2 6
R_v_M2_4_4 400_2400_M2 400_2500_M2 6
R_v_M2_5_4 500_2400_M2 500_2500_M2 6
R_v_M2_6_4 600_2400_M2 600_2500_M2 6
R_v_M2_7_4 700_2400_M2 700_2500_M2 6
R_v_M2_8_4 800_2400_M2 800_2500_M2 6
R_v_M2_9_4 900_2400_M2 900_2500_M2 6
R_v_M2_0_5 0_2500_M2 0_2600_M2 6
R_v_M2_1_5 100_2500_M2 100_2600_M2 6
R_v_M2_2_5 200_2500_M2 200_2600_M2 6
R_v_M2_3_5 300_2500_M2 300_2600_M2 6
R_v_M2_4_5 400_2500_M2 400_2600_M2 6
R_v_M2_5_5 500_2500_M2 500_2600_M2 6
R_v_M2_6_5 600_2500_M2 600_2600_M2 6
R_v_M2_7_5 700_2500_M2 700_2600_M2 6
R_v_M2_8_5 800_2500_M2 800_2600_M2 6
R_v_M2_9_5 900_2500_M2 900_2600_M2 6
R_v_M2_0_6 0_2600_M2 0_2700_M2 6
R_v_M2_1_6 100_2600_M2 100_2700_M2 6
R_v_M2_2_6 200_2600_M2 200_2700_M2 6
R_v_M2_3_6 300_2600_M2 300_2700_M2 6
R_v_M2_4_6 400_2600_M2 400_2700_M2 6
R_v_M2_5_6 500_2600_M2 500_2700_M2 6
R_v_M2_6_6 600_2600_M2 600_2700_M2 6
R_v_M2_7_6 700_2600_M2 700_2700_M2 6
R_v_M2_8_6 800_2600_M2 800_2700_M2 6
R_v_M2_9_6 900_2600_M2 900_2700_M2 6
R_v_M2_0_7 0_2700_M2 0_2800_M2 6
R_v_M2_1_7 100_2700_M2 100_2800_M2 6
R_v_M2_2_7 200_2700_M2 200_2800_M2 6
R_v_M2_3_7 300_2700_M2 300_2800_M2 6
R_v_M2_4_7 400_2700_M2 400_2800_M2 6
R_v_M2_5_7 500_2700_M2 500_2800_M2 6
R_v_M2_6_7 600_2700_M2 600_2800_M2 6
R_v_M2_7_7 700_2700_M2 700_2800_M2 6
R_v_M2_8_7 800_2700_M2 800_2800_M2 6
R_v_M2_9_7 900_2700_M2 900_2800_M2 6
R_v_M2_0_8 0_2800_M2 0_2900_M2 6
R_v_M2_1_8 100_2800_M2 100_2900_M2 6
R_v_M2_2_8 200_2800_M2 200_2900_M2 6
R_v_M2_3_8 300_2800_M2 300_2900_M2 6
R_v_M2_4_8 400_2800_M2 400_2900_M2 6
R_v_M2_5_8 500_2800_M2 500_2900_M2 6
R_v_M2_6_8 600_2800_M2 600_2900_M2 6
R_v_M2_7_8 700_2800_M2 700_2900_M2 6
R_v_M2_8_8 800_2800_M2 800_2900_M2 6
R_v_M2_9_8 900_2800_M2 900_2900_M2 6
* Ground capacitors (C=3.0 fF)
C_g_M2_0_0 0_2000_M2 0 3e-15
C_g_M2_1_0 100_2000_M2 0 3e-15
C_g_M2_2_0 200_2000_M2 0 3e-15
C_g_M2_3_0 300_2000_M2 0 3e-15
C_g_M2_4_0 400_2000_M2 0 3e-15
C_g_M2_5_0 500_2000_M2 0 3e-15
C_g_M2_6_0 600_2000_M2 0 3e-15
C_g_M2_7_0 700_2000_M2 0 3e-15
C_g_M2_8_0 800_2000_M2 0 3e-15
C_g_M2_9_0 900_2000_M2 0 3e-15
C_g_M2_0_1 0_2100_M2 0 3e-15
C_g_M2_1_1 100_2100_M2 0 3e-15
C_g_M2_2_1 200_2100_M2 0 3e-15
C_g_M2_3_1 300_2100_M2 0 3e-15
C_g_M2_4_1 400_2100_M2 0 3e-15
C_g_M2_5_1 500_2100_M2 0 3e-15
C_g_M2_6_1 600_2100_M2 0 3e-15
C_g_M2_7_1 700_2100_M2 0 3e-15
C_g_M2_8_1 800_2100_M2 0 3e-15
C_g_M2_9_1 900_2100_M2 0 3e-15
C_g_M2_0_2 0_2200_M2 0 3e-15
C_g_M2_1_2 100_2200_M2 0 3e-15
C_g_M2_2_2 200_2200_M2 0 3e-15
C_g_M2_3_2 300_2200_M2 0 3e-15
C_g_M2_4_2 400_2200_M2 0 3e-15
C_g_M2_5_2 500_2200_M2 0 3e-15
C_g_M2_6_2 600_2200_M2 0 3e-15
C_g_M2_7_2 700_2200_M2 0 3e-15
C_g_M2_8_2 800_2200_M2 0 3e-15
C_g_M2_9_2 900_2200_M2 0 3e-15
C_g_M2_0_3 0_2300_M2 0 3e-15
C_g_M2_1_3 100_2300_M2 0 3e-15
C_g_M2_2_3 200_2300_M2 0 3e-15
C_g_M2_3_3 300_2300_M2 0 3e-15
C_g_M2_4_3 400_2300_M2 0 3e-15
C_g_M2_5_3 500_2300_M2 0 3e-15
C_g_M2_6_3 600_2300_M2 0 3e-15
C_g_M2_7_3 700_2300_M2 0 3e-15
C_g_M2_8_3 800_2300_M2 0 3e-15
C_g_M2_9_3 900_2300_M2 0 3e-15
C_g_M2_0_4 0_2400_M2 0 3e-15
C_g_M2_1_4 100_2400_M2 0 3e-15
C_g_M2_2_4 200_2400_M2 0 3e-15
C_g_M2_3_4 300_2400_M2 0 3e-15
C_g_M2_4_4 400_2400_M2 0 3e-15
C_g_M2_5_4 500_2400_M2 0 3e-15
C_g_M2_6_4 600_2400_M2 0 3e-15
C_g_M2_7_4 700_2400_M2 0 3e-15
C_g_M2_8_4 800_2400_M2 0 3e-15
C_g_M2_9_4 900_2400_M2 0 3e-15
C_g_M2_0_5 0_2500_M2 0 3e-15
C_g_M2_1_5 100_2500_M2 0 3e-15
C_g_M2_2_5 200_2500_M2 0 3e-15
C_g_M2_3_5 300_2500_M2 0 3e-15
C_g_M2_4_5 400_2500_M2 0 3e-15
C_g_M2_5_5 500_2500_M2 0 3e-15
C_g_M2_6_5 600_2500_M2 0 3e-15
C_g_M2_7_5 700_2500_M2 0 3e-15
C_g_M2_8_5 800_2500_M2 0 3e-15
C_g_M2_9_5 900_2500_M2 0 3e-15
C_g_M2_0_6 0_2600_M2 0 3e-15
C_g_M2_1_6 100_2600_M2 0 3e-15
C_g_M2_2_6 200_2600_M2 0 3e-15
C_g_M2_3_6 300_2600_M2 0 3e-15
C_g_M2_4_6 400_2600_M2 0 3e-15
C_g_M2_5_6 500_2600_M2 0 3e-15
C_g_M2_6_6 600_2600_M2 0 3e-15
C_g_M2_7_6 700_2600_M2 0 3e-15
C_g_M2_8_6 800_2600_M2 0 3e-15
C_g_M2_9_6 900_2600_M2 0 3e-15
C_g_M2_0_7 0_2700_M2 0 3e-15
C_g_M2_1_7 100_2700_M2 0 3e-15
C_g_M2_2_7 200_2700_M2 0 3e-15
C_g_M2_3_7 300_2700_M2 0 3e-15
C_g_M2_4_7 400_2700_M2 0 3e-15
C_g_M2_5_7 500_2700_M2 0 3e-15
C_g_M2_6_7 600_2700_M2 0 3e-15
C_g_M2_7_7 700_2700_M2 0 3e-15
C_g_M2_8_7 800_2700_M2 0 3e-15
C_g_M2_9_7 900_2700_M2 0 3e-15
C_g_M2_0_8 0_2800_M2 0 3e-15
C_g_M2_1_8 100_2800_M2 0 3e-15
C_g_M2_2_8 200_2800_M2 0 3e-15
C_g_M2_3_8 300_2800_M2 0 3e-15
C_g_M2_4_8 400_2800_M2 0 3e-15
C_g_M2_5_8 500_2800_M2 0 3e-15
C_g_M2_6_8 600_2800_M2 0 3e-15
C_g_M2_7_8 700_2800_M2 0 3e-15
C_g_M2_8_8 800_2800_M2 0 3e-15
C_g_M2_9_8 900_2800_M2 0 3e-15
C_g_M2_0_9 0_2900_M2 0 3e-15
C_g_M2_1_9 100_2900_M2 0 3e-15
C_g_M2_2_9 200_2900_M2 0 3e-15
C_g_M2_3_9 300_2900_M2 0 3e-15
C_g_M2_4_9 400_2900_M2 0 3e-15
C_g_M2_5_9 500_2900_M2 0 3e-15
C_g_M2_6_9 600_2900_M2 0 3e-15
C_g_M2_7_9 700_2900_M2 0 3e-15
C_g_M2_8_9 800_2900_M2 0 3e-15
C_g_M2_9_9 900_2900_M2 0 3e-15
* Coupling capacitors (C=1.0 fF)
C_coup_M2_0_0 0_2000_M2 100_2000_M2 1e-15
C_coup_M2_2_0 200_2000_M2 300_2000_M2 1e-15
C_coup_M2_4_0 400_2000_M2 500_2000_M2 1e-15
C_coup_M2_6_0 600_2000_M2 700_2000_M2 1e-15
C_coup_M2_8_0 800_2000_M2 900_2000_M2 1e-15
C_coup_M2_0_1 0_2100_M2 100_2100_M2 1e-15
C_coup_M2_2_1 200_2100_M2 300_2100_M2 1e-15
C_coup_M2_4_1 400_2100_M2 500_2100_M2 1e-15
C_coup_M2_6_1 600_2100_M2 700_2100_M2 1e-15
C_coup_M2_8_1 800_2100_M2 900_2100_M2 1e-15
C_coup_M2_0_2 0_2200_M2 100_2200_M2 1e-15
C_coup_M2_2_2 200_2200_M2 300_2200_M2 1e-15
C_coup_M2_4_2 400_2200_M2 500_2200_M2 1e-15
C_coup_M2_6_2 600_2200_M2 700_2200_M2 1e-15
C_coup_M2_8_2 800_2200_M2 900_2200_M2 1e-15
C_coup_M2_0_3 0_2300_M2 100_2300_M2 1e-15
C_coup_M2_2_3 200_2300_M2 300_2300_M2 1e-15
C_coup_M2_4_3 400_2300_M2 500_2300_M2 1e-15
C_coup_M2_6_3 600_2300_M2 700_2300_M2 1e-15
C_coup_M2_8_3 800_2300_M2 900_2300_M2 1e-15
C_coup_M2_0_4 0_2400_M2 100_2400_M2 1e-15
C_coup_M2_2_4 200_2400_M2 300_2400_M2 1e-15
C_coup_M2_4_4 400_2400_M2 500_2400_M2 1e-15
C_coup_M2_6_4 600_2400_M2 700_2400_M2 1e-15
C_coup_M2_8_4 800_2400_M2 900_2400_M2 1e-15
C_coup_M2_0_5 0_2500_M2 100_2500_M2 1e-15
C_coup_M2_2_5 200_2500_M2 300_2500_M2 1e-15
C_coup_M2_4_5 400_2500_M2 500_2500_M2 1e-15
C_coup_M2_6_5 600_2500_M2 700_2500_M2 1e-15
C_coup_M2_8_5 800_2500_M2 900_2500_M2 1e-15
C_coup_M2_0_6 0_2600_M2 100_2600_M2 1e-15
C_coup_M2_2_6 200_2600_M2 300_2600_M2 1e-15
C_coup_M2_4_6 400_2600_M2 500_2600_M2 1e-15
C_coup_M2_6_6 600_2600_M2 700_2600_M2 1e-15
C_coup_M2_8_6 800_2600_M2 900_2600_M2 1e-15
C_coup_M2_0_7 0_2700_M2 100_2700_M2 1e-15
C_coup_M2_2_7 200_2700_M2 300_2700_M2 1e-15
C_coup_M2_4_7 400_2700_M2 500_2700_M2 1e-15
C_coup_M2_6_7 600_2700_M2 700_2700_M2 1e-15
C_coup_M2_8_7 800_2700_M2 900_2700_M2 1e-15
C_coup_M2_0_8 0_2800_M2 100_2800_M2 1e-15
C_coup_M2_2_8 200_2800_M2 300_2800_M2 1e-15
C_coup_M2_4_8 400_2800_M2 500_2800_M2 1e-15
C_coup_M2_6_8 600_2800_M2 700_2800_M2 1e-15
C_coup_M2_8_8 800_2800_M2 900_2800_M2 1e-15
C_coup_M2_0_9 0_2900_M2 100_2900_M2 1e-15
C_coup_M2_2_9 200_2900_M2 300_2900_M2 1e-15
C_coup_M2_4_9 400_2900_M2 500_2900_M2 1e-15
C_coup_M2_6_9 600_2900_M2 700_2900_M2 1e-15
C_coup_M2_8_9 800_2900_M2 900_2900_M2 1e-15

* ========== Layer M3 ==========
* Horizontal resistors (R=3 Ohm)
R_h_M3_0_0 0_2000_M3 100_2000_M3 3
R_h_M3_1_0 100_2000_M3 200_2000_M3 3
R_h_M3_2_0 200_2000_M3 300_2000_M3 3
R_h_M3_3_0 300_2000_M3 400_2000_M3 3
R_h_M3_4_0 400_2000_M3 500_2000_M3 3
R_h_M3_5_0 500_2000_M3 600_2000_M3 3
R_h_M3_6_0 600_2000_M3 700_2000_M3 3
R_h_M3_7_0 700_2000_M3 800_2000_M3 3
R_h_M3_8_0 800_2000_M3 900_2000_M3 3
R_h_M3_0_1 0_2100_M3 100_2100_M3 3
R_h_M3_1_1 100_2100_M3 200_2100_M3 3
R_h_M3_2_1 200_2100_M3 300_2100_M3 3
R_h_M3_3_1 300_2100_M3 400_2100_M3 3
R_h_M3_4_1 400_2100_M3 500_2100_M3 3
R_h_M3_5_1 500_2100_M3 600_2100_M3 3
R_h_M3_6_1 600_2100_M3 700_2100_M3 3
R_h_M3_7_1 700_2100_M3 800_2100_M3 3
R_h_M3_8_1 800_2100_M3 900_2100_M3 3
R_h_M3_0_2 0_2200_M3 100_2200_M3 3
R_h_M3_1_2 100_2200_M3 200_2200_M3 3
R_h_M3_2_2 200_2200_M3 300_2200_M3 3
R_h_M3_3_2 300_2200_M3 400_2200_M3 3
R_h_M3_4_2 400_2200_M3 500_2200_M3 3
R_h_M3_5_2 500_2200_M3 600_2200_M3 3
R_h_M3_6_2 600_2200_M3 700_2200_M3 3
R_h_M3_7_2 700_2200_M3 800_2200_M3 3
R_h_M3_8_2 800_2200_M3 900_2200_M3 3
R_h_M3_0_3 0_2300_M3 100_2300_M3 3
R_h_M3_1_3 100_2300_M3 200_2300_M3 3
R_h_M3_2_3 200_2300_M3 300_2300_M3 3
R_h_M3_3_3 300_2300_M3 400_2300_M3 3
R_h_M3_4_3 400_2300_M3 500_2300_M3 3
R_h_M3_5_3 500_2300_M3 600_2300_M3 3
R_h_M3_6_3 600_2300_M3 700_2300_M3 3
R_h_M3_7_3 700_2300_M3 800_2300_M3 3
R_h_M3_8_3 800_2300_M3 900_2300_M3 3
R_h_M3_0_4 0_2400_M3 100_2400_M3 3
R_h_M3_1_4 100_2400_M3 200_2400_M3 3
R_h_M3_2_4 200_2400_M3 300_2400_M3 3
R_h_M3_3_4 300_2400_M3 400_2400_M3 3
R_h_M3_4_4 400_2400_M3 500_2400_M3 3
R_h_M3_5_4 500_2400_M3 600_2400_M3 3
R_h_M3_6_4 600_2400_M3 700_2400_M3 3
R_h_M3_7_4 700_2400_M3 800_2400_M3 3
R_h_M3_8_4 800_2400_M3 900_2400_M3 3
R_h_M3_0_5 0_2500_M3 100_2500_M3 3
R_h_M3_1_5 100_2500_M3 200_2500_M3 3
R_h_M3_2_5 200_2500_M3 300_2500_M3 3
R_h_M3_3_5 300_2500_M3 400_2500_M3 3
R_h_M3_4_5 400_2500_M3 500_2500_M3 3
R_h_M3_5_5 500_2500_M3 600_2500_M3 3
R_h_M3_6_5 600_2500_M3 700_2500_M3 3
R_h_M3_7_5 700_2500_M3 800_2500_M3 3
R_h_M3_8_5 800_2500_M3 900_2500_M3 3
R_h_M3_0_6 0_2600_M3 100_2600_M3 3
R_h_M3_1_6 100_2600_M3 200_2600_M3 3
R_h_M3_2_6 200_2600_M3 300_2600_M3 3
R_h_M3_3_6 300_2600_M3 400_2600_M3 3
R_h_M3_4_6 400_2600_M3 500_2600_M3 3
R_h_M3_5_6 500_2600_M3 600_2600_M3 3
R_h_M3_6_6 600_2600_M3 700_2600_M3 3
R_h_M3_7_6 700_2600_M3 800_2600_M3 3
R_h_M3_8_6 800_2600_M3 900_2600_M3 3
R_h_M3_0_7 0_2700_M3 100_2700_M3 3
R_h_M3_1_7 100_2700_M3 200_2700_M3 3
R_h_M3_2_7 200_2700_M3 300_2700_M3 3
R_h_M3_3_7 300_2700_M3 400_2700_M3 3
R_h_M3_4_7 400_2700_M3 500_2700_M3 3
R_h_M3_5_7 500_2700_M3 600_2700_M3 3
R_h_M3_6_7 600_2700_M3 700_2700_M3 3
R_h_M3_7_7 700_2700_M3 800_2700_M3 3
R_h_M3_8_7 800_2700_M3 900_2700_M3 3
R_h_M3_0_8 0_2800_M3 100_2800_M3 3
R_h_M3_1_8 100_2800_M3 200_2800_M3 3
R_h_M3_2_8 200_2800_M3 300_2800_M3 3
R_h_M3_3_8 300_2800_M3 400_2800_M3 3
R_h_M3_4_8 400_2800_M3 500_2800_M3 3
R_h_M3_5_8 500_2800_M3 600_2800_M3 3
R_h_M3_6_8 600_2800_M3 700_2800_M3 3
R_h_M3_7_8 700_2800_M3 800_2800_M3 3
R_h_M3_8_8 800_2800_M3 900_2800_M3 3
R_h_M3_0_9 0_2900_M3 100_2900_M3 3
R_h_M3_1_9 100_2900_M3 200_2900_M3 3
R_h_M3_2_9 200_2900_M3 300_2900_M3 3
R_h_M3_3_9 300_2900_M3 400_2900_M3 3
R_h_M3_4_9 400_2900_M3 500_2900_M3 3
R_h_M3_5_9 500_2900_M3 600_2900_M3 3
R_h_M3_6_9 600_2900_M3 700_2900_M3 3
R_h_M3_7_9 700_2900_M3 800_2900_M3 3
R_h_M3_8_9 800_2900_M3 900_2900_M3 3
* Vertical resistors (R=4 Ohm)
R_v_M3_0_0 0_2000_M3 0_2100_M3 4
R_v_M3_1_0 100_2000_M3 100_2100_M3 4
R_v_M3_2_0 200_2000_M3 200_2100_M3 4
R_v_M3_3_0 300_2000_M3 300_2100_M3 4
R_v_M3_4_0 400_2000_M3 400_2100_M3 4
R_v_M3_5_0 500_2000_M3 500_2100_M3 4
R_v_M3_6_0 600_2000_M3 600_2100_M3 4
R_v_M3_7_0 700_2000_M3 700_2100_M3 4
R_v_M3_8_0 800_2000_M3 800_2100_M3 4
R_v_M3_9_0 900_2000_M3 900_2100_M3 4
R_v_M3_0_1 0_2100_M3 0_2200_M3 4
R_v_M3_1_1 100_2100_M3 100_2200_M3 4
R_v_M3_2_1 200_2100_M3 200_2200_M3 4
R_v_M3_3_1 300_2100_M3 300_2200_M3 4
R_v_M3_4_1 400_2100_M3 400_2200_M3 4
R_v_M3_5_1 500_2100_M3 500_2200_M3 4
R_v_M3_6_1 600_2100_M3 600_2200_M3 4
R_v_M3_7_1 700_2100_M3 700_2200_M3 4
R_v_M3_8_1 800_2100_M3 800_2200_M3 4
R_v_M3_9_1 900_2100_M3 900_2200_M3 4
R_v_M3_0_2 0_2200_M3 0_2300_M3 4
R_v_M3_1_2 100_2200_M3 100_2300_M3 4
R_v_M3_2_2 200_2200_M3 200_2300_M3 4
R_v_M3_3_2 300_2200_M3 300_2300_M3 4
R_v_M3_4_2 400_2200_M3 400_2300_M3 4
R_v_M3_5_2 500_2200_M3 500_2300_M3 4
R_v_M3_6_2 600_2200_M3 600_2300_M3 4
R_v_M3_7_2 700_2200_M3 700_2300_M3 4
R_v_M3_8_2 800_2200_M3 800_2300_M3 4
R_v_M3_9_2 900_2200_M3 900_2300_M3 4
R_v_M3_0_3 0_2300_M3 0_2400_M3 4
R_v_M3_1_3 100_2300_M3 100_2400_M3 4
R_v_M3_2_3 200_2300_M3 200_2400_M3 4
R_v_M3_3_3 300_2300_M3 300_2400_M3 4
R_v_M3_4_3 400_2300_M3 400_2400_M3 4
R_v_M3_5_3 500_2300_M3 500_2400_M3 4
R_v_M3_6_3 600_2300_M3 600_2400_M3 4
R_v_M3_7_3 700_2300_M3 700_2400_M3 4
R_v_M3_8_3 800_2300_M3 800_2400_M3 4
R_v_M3_9_3 900_2300_M3 900_2400_M3 4
R_v_M3_0_4 0_2400_M3 0_2500_M3 4
R_v_M3_1_4 100_2400_M3 100_2500_M3 4
R_v_M3_2_4 200_2400_M3 200_2500_M3 4
R_v_M3_3_4 300_2400_M3 300_2500_M3 4
R_v_M3_4_4 400_2400_M3 400_2500_M3 4
R_v_M3_5_4 500_2400_M3 500_2500_M3 4
R_v_M3_6_4 600_2400_M3 600_2500_M3 4
R_v_M3_7_4 700_2400_M3 700_2500_M3 4
R_v_M3_8_4 800_2400_M3 800_2500_M3 4
R_v_M3_9_4 900_2400_M3 900_2500_M3 4
R_v_M3_0_5 0_2500_M3 0_2600_M3 4
R_v_M3_1_5 100_2500_M3 100_2600_M3 4
R_v_M3_2_5 200_2500_M3 200_2600_M3 4
R_v_M3_3_5 300_2500_M3 300_2600_M3 4
R_v_M3_4_5 400_2500_M3 400_2600_M3 4
R_v_M3_5_5 500_2500_M3 500_2600_M3 4
R_v_M3_6_5 600_2500_M3 600_2600_M3 4
R_v_M3_7_5 700_2500_M3 700_2600_M3 4
R_v_M3_8_5 800_2500_M3 800_2600_M3 4
R_v_M3_9_5 900_2500_M3 900_2600_M3 4
R_v_M3_0_6 0_2600_M3 0_2700_M3 4
R_v_M3_1_6 100_2600_M3 100_2700_M3 4
R_v_M3_2_6 200_2600_M3 200_2700_M3 4
R_v_M3_3_6 300_2600_M3 300_2700_M3 4
R_v_M3_4_6 400_2600_M3 400_2700_M3 4
R_v_M3_5_6 500_2600_M3 500_2700_M3 4
R_v_M3_6_6 600_2600_M3 600_2700_M3 4
R_v_M3_7_6 700_2600_M3 700_2700_M3 4
R_v_M3_8_6 800_2600_M3 800_2700_M3 4
R_v_M3_9_6 900_2600_M3 900_2700_M3 4
R_v_M3_0_7 0_2700_M3 0_2800_M3 4
R_v_M3_1_7 100_2700_M3 100_2800_M3 4
R_v_M3_2_7 200_2700_M3 200_2800_M3 4
R_v_M3_3_7 300_2700_M3 300_2800_M3 4
R_v_M3_4_7 400_2700_M3 400_2800_M3 4
R_v_M3_5_7 500_2700_M3 500_2800_M3 4
R_v_M3_6_7 600_2700_M3 600_2800_M3 4
R_v_M3_7_7 700_2700_M3 700_2800_M3 4
R_v_M3_8_7 800_2700_M3 800_2800_M3 4
R_v_M3_9_7 900_2700_M3 900_2800_M3 4
R_v_M3_0_8 0_2800_M3 0_2900_M3 4
R_v_M3_1_8 100_2800_M3 100_2900_M3 4
R_v_M3_2_8 200_2800_M3 200_2900_M3 4
R_v_M3_3_8 300_2800_M3 300_2900_M3 4
R_v_M3_4_8 400_2800_M3 400_2900_M3 4
R_v_M3_5_8 500_2800_M3 500_2900_M3 4
R_v_M3_6_8 600_2800_M3 600_2900_M3 4
R_v_M3_7_8 700_2800_M3 700_2900_M3 4
R_v_M3_8_8 800_2800_M3 800_2900_M3 4
R_v_M3_9_8 900_2800_M3 900_2900_M3 4
* Ground capacitors (C=2.0 fF)
C_g_M3_0_0 0_2000_M3 0 2e-15
C_g_M3_1_0 100_2000_M3 0 2e-15
C_g_M3_2_0 200_2000_M3 0 2e-15
C_g_M3_3_0 300_2000_M3 0 2e-15
C_g_M3_4_0 400_2000_M3 0 2e-15
C_g_M3_5_0 500_2000_M3 0 2e-15
C_g_M3_6_0 600_2000_M3 0 2e-15
C_g_M3_7_0 700_2000_M3 0 2e-15
C_g_M3_8_0 800_2000_M3 0 2e-15
C_g_M3_9_0 900_2000_M3 0 2e-15
C_g_M3_0_1 0_2100_M3 0 2e-15
C_g_M3_1_1 100_2100_M3 0 2e-15
C_g_M3_2_1 200_2100_M3 0 2e-15
C_g_M3_3_1 300_2100_M3 0 2e-15
C_g_M3_4_1 400_2100_M3 0 2e-15
C_g_M3_5_1 500_2100_M3 0 2e-15
C_g_M3_6_1 600_2100_M3 0 2e-15
C_g_M3_7_1 700_2100_M3 0 2e-15
C_g_M3_8_1 800_2100_M3 0 2e-15
C_g_M3_9_1 900_2100_M3 0 2e-15
C_g_M3_0_2 0_2200_M3 0 2e-15
C_g_M3_1_2 100_2200_M3 0 2e-15
C_g_M3_2_2 200_2200_M3 0 2e-15
C_g_M3_3_2 300_2200_M3 0 2e-15
C_g_M3_4_2 400_2200_M3 0 2e-15
C_g_M3_5_2 500_2200_M3 0 2e-15
C_g_M3_6_2 600_2200_M3 0 2e-15
C_g_M3_7_2 700_2200_M3 0 2e-15
C_g_M3_8_2 800_2200_M3 0 2e-15
C_g_M3_9_2 900_2200_M3 0 2e-15
C_g_M3_0_3 0_2300_M3 0 2e-15
C_g_M3_1_3 100_2300_M3 0 2e-15
C_g_M3_2_3 200_2300_M3 0 2e-15
C_g_M3_3_3 300_2300_M3 0 2e-15
C_g_M3_4_3 400_2300_M3 0 2e-15
C_g_M3_5_3 500_2300_M3 0 2e-15
C_g_M3_6_3 600_2300_M3 0 2e-15
C_g_M3_7_3 700_2300_M3 0 2e-15
C_g_M3_8_3 800_2300_M3 0 2e-15
C_g_M3_9_3 900_2300_M3 0 2e-15
C_g_M3_0_4 0_2400_M3 0 2e-15
C_g_M3_1_4 100_2400_M3 0 2e-15
C_g_M3_2_4 200_2400_M3 0 2e-15
C_g_M3_3_4 300_2400_M3 0 2e-15
C_g_M3_4_4 400_2400_M3 0 2e-15
C_g_M3_5_4 500_2400_M3 0 2e-15
C_g_M3_6_4 600_2400_M3 0 2e-15
C_g_M3_7_4 700_2400_M3 0 2e-15
C_g_M3_8_4 800_2400_M3 0 2e-15
C_g_M3_9_4 900_2400_M3 0 2e-15
C_g_M3_0_5 0_2500_M3 0 2e-15
C_g_M3_1_5 100_2500_M3 0 2e-15
C_g_M3_2_5 200_2500_M3 0 2e-15
C_g_M3_3_5 300_2500_M3 0 2e-15
C_g_M3_4_5 400_2500_M3 0 2e-15
C_g_M3_5_5 500_2500_M3 0 2e-15
C_g_M3_6_5 600_2500_M3 0 2e-15
C_g_M3_7_5 700_2500_M3 0 2e-15
C_g_M3_8_5 800_2500_M3 0 2e-15
C_g_M3_9_5 900_2500_M3 0 2e-15
C_g_M3_0_6 0_2600_M3 0 2e-15
C_g_M3_1_6 100_2600_M3 0 2e-15
C_g_M3_2_6 200_2600_M3 0 2e-15
C_g_M3_3_6 300_2600_M3 0 2e-15
C_g_M3_4_6 400_2600_M3 0 2e-15
C_g_M3_5_6 500_2600_M3 0 2e-15
C_g_M3_6_6 600_2600_M3 0 2e-15
C_g_M3_7_6 700_2600_M3 0 2e-15
C_g_M3_8_6 800_2600_M3 0 2e-15
C_g_M3_9_6 900_2600_M3 0 2e-15
C_g_M3_0_7 0_2700_M3 0 2e-15
C_g_M3_1_7 100_2700_M3 0 2e-15
C_g_M3_2_7 200_2700_M3 0 2e-15
C_g_M3_3_7 300_2700_M3 0 2e-15
C_g_M3_4_7 400_2700_M3 0 2e-15
C_g_M3_5_7 500_2700_M3 0 2e-15
C_g_M3_6_7 600_2700_M3 0 2e-15
C_g_M3_7_7 700_2700_M3 0 2e-15
C_g_M3_8_7 800_2700_M3 0 2e-15
C_g_M3_9_7 900_2700_M3 0 2e-15
C_g_M3_0_8 0_2800_M3 0 2e-15
C_g_M3_1_8 100_2800_M3 0 2e-15
C_g_M3_2_8 200_2800_M3 0 2e-15
C_g_M3_3_8 300_2800_M3 0 2e-15
C_g_M3_4_8 400_2800_M3 0 2e-15
C_g_M3_5_8 500_2800_M3 0 2e-15
C_g_M3_6_8 600_2800_M3 0 2e-15
C_g_M3_7_8 700_2800_M3 0 2e-15
C_g_M3_8_8 800_2800_M3 0 2e-15
C_g_M3_9_8 900_2800_M3 0 2e-15
C_g_M3_0_9 0_2900_M3 0 2e-15
C_g_M3_1_9 100_2900_M3 0 2e-15
C_g_M3_2_9 200_2900_M3 0 2e-15
C_g_M3_3_9 300_2900_M3 0 2e-15
C_g_M3_4_9 400_2900_M3 0 2e-15
C_g_M3_5_9 500_2900_M3 0 2e-15
C_g_M3_6_9 600_2900_M3 0 2e-15
C_g_M3_7_9 700_2900_M3 0 2e-15
C_g_M3_8_9 800_2900_M3 0 2e-15
C_g_M3_9_9 900_2900_M3 0 2e-15
* Coupling capacitors (C=1.0 fF)
C_coup_M3_0_0 0_2000_M3 100_2000_M3 1e-15
C_coup_M3_2_0 200_2000_M3 300_2000_M3 1e-15
C_coup_M3_4_0 400_2000_M3 500_2000_M3 1e-15
C_coup_M3_6_0 600_2000_M3 700_2000_M3 1e-15
C_coup_M3_8_0 800_2000_M3 900_2000_M3 1e-15
C_coup_M3_0_1 0_2100_M3 100_2100_M3 1e-15
C_coup_M3_2_1 200_2100_M3 300_2100_M3 1e-15
C_coup_M3_4_1 400_2100_M3 500_2100_M3 1e-15
C_coup_M3_6_1 600_2100_M3 700_2100_M3 1e-15
C_coup_M3_8_1 800_2100_M3 900_2100_M3 1e-15
C_coup_M3_0_2 0_2200_M3 100_2200_M3 1e-15
C_coup_M3_2_2 200_2200_M3 300_2200_M3 1e-15
C_coup_M3_4_2 400_2200_M3 500_2200_M3 1e-15
C_coup_M3_6_2 600_2200_M3 700_2200_M3 1e-15
C_coup_M3_8_2 800_2200_M3 900_2200_M3 1e-15
C_coup_M3_0_3 0_2300_M3 100_2300_M3 1e-15
C_coup_M3_2_3 200_2300_M3 300_2300_M3 1e-15
C_coup_M3_4_3 400_2300_M3 500_2300_M3 1e-15
C_coup_M3_6_3 600_2300_M3 700_2300_M3 1e-15
C_coup_M3_8_3 800_2300_M3 900_2300_M3 1e-15
C_coup_M3_0_4 0_2400_M3 100_2400_M3 1e-15
C_coup_M3_2_4 200_2400_M3 300_2400_M3 1e-15
C_coup_M3_4_4 400_2400_M3 500_2400_M3 1e-15
C_coup_M3_6_4 600_2400_M3 700_2400_M3 1e-15
C_coup_M3_8_4 800_2400_M3 900_2400_M3 1e-15
C_coup_M3_0_5 0_2500_M3 100_2500_M3 1e-15
C_coup_M3_2_5 200_2500_M3 300_2500_M3 1e-15
C_coup_M3_4_5 400_2500_M3 500_2500_M3 1e-15
C_coup_M3_6_5 600_2500_M3 700_2500_M3 1e-15
C_coup_M3_8_5 800_2500_M3 900_2500_M3 1e-15
C_coup_M3_0_6 0_2600_M3 100_2600_M3 1e-15
C_coup_M3_2_6 200_2600_M3 300_2600_M3 1e-15
C_coup_M3_4_6 400_2600_M3 500_2600_M3 1e-15
C_coup_M3_6_6 600_2600_M3 700_2600_M3 1e-15
C_coup_M3_8_6 800_2600_M3 900_2600_M3 1e-15
C_coup_M3_0_7 0_2700_M3 100_2700_M3 1e-15
C_coup_M3_2_7 200_2700_M3 300_2700_M3 1e-15
C_coup_M3_4_7 400_2700_M3 500_2700_M3 1e-15
C_coup_M3_6_7 600_2700_M3 700_2700_M3 1e-15
C_coup_M3_8_7 800_2700_M3 900_2700_M3 1e-15
C_coup_M3_0_8 0_2800_M3 100_2800_M3 1e-15
C_coup_M3_2_8 200_2800_M3 300_2800_M3 1e-15
C_coup_M3_4_8 400_2800_M3 500_2800_M3 1e-15
C_coup_M3_6_8 600_2800_M3 700_2800_M3 1e-15
C_coup_M3_8_8 800_2800_M3 900_2800_M3 1e-15
C_coup_M3_0_9 0_2900_M3 100_2900_M3 1e-15
C_coup_M3_2_9 200_2900_M3 300_2900_M3 1e-15
C_coup_M3_4_9 400_2900_M3 500_2900_M3 1e-15
C_coup_M3_6_9 600_2900_M3 700_2900_M3 1e-15
C_coup_M3_8_9 800_2900_M3 900_2900_M3 1e-15

* ========== Via connections ==========
* Vias M1 to M2 (R=0.5 Ohm)
R_via_M1_M2_0_0 0_2000_M1 0_2000_M2 0.5
R_via_M1_M2_2_0 200_2000_M1 200_2000_M2 0.5
R_via_M1_M2_4_0 400_2000_M1 400_2000_M2 0.5
R_via_M1_M2_6_0 600_2000_M1 600_2000_M2 0.5
R_via_M1_M2_8_0 800_2000_M1 800_2000_M2 0.5
R_via_M1_M2_0_2 0_2200_M1 0_2200_M2 0.5
R_via_M1_M2_2_2 200_2200_M1 200_2200_M2 0.5
R_via_M1_M2_4_2 400_2200_M1 400_2200_M2 0.5
R_via_M1_M2_6_2 600_2200_M1 600_2200_M2 0.5
R_via_M1_M2_8_2 800_2200_M1 800_2200_M2 0.5
R_via_M1_M2_0_4 0_2400_M1 0_2400_M2 0.5
R_via_M1_M2_2_4 200_2400_M1 200_2400_M2 0.5
R_via_M1_M2_4_4 400_2400_M1 400_2400_M2 0.5
R_via_M1_M2_6_4 600_2400_M1 600_2400_M2 0.5
R_via_M1_M2_8_4 800_2400_M1 800_2400_M2 0.5
R_via_M1_M2_0_6 0_2600_M1 0_2600_M2 0.5
R_via_M1_M2_2_6 200_2600_M1 200_2600_M2 0.5
R_via_M1_M2_4_6 400_2600_M1 400_2600_M2 0.5
R_via_M1_M2_6_6 600_2600_M1 600_2600_M2 0.5
R_via_M1_M2_8_6 800_2600_M1 800_2600_M2 0.5
R_via_M1_M2_0_8 0_2800_M1 0_2800_M2 0.5
R_via_M1_M2_2_8 200_2800_M1 200_2800_M2 0.5
R_via_M1_M2_4_8 400_2800_M1 400_2800_M2 0.5
R_via_M1_M2_6_8 600_2800_M1 600_2800_M2 0.5
R_via_M1_M2_8_8 800_2800_M1 800_2800_M2 0.5
* Vias M2 to M3 (R=0.3 Ohm)
R_via_M2_M3_0_0 0_2000_M2 0_2000_M3 0.3
R_via_M2_M3_2_0 200_2000_M2 200_2000_M3 0.3
R_via_M2_M3_4_0 400_2000_M2 400_2000_M3 0.3
R_via_M2_M3_6_0 600_2000_M2 600_2000_M3 0.3
R_via_M2_M3_8_0 800_2000_M2 800_2000_M3 0.3
R_via_M2_M3_0_2 0_2200_M2 0_2200_M3 0.3
R_via_M2_M3_2_2 200_2200_M2 200_2200_M3 0.3
R_via_M2_M3_4_2 400_2200_M2 400_2200_M3 0.3
R_via_M2_M3_6_2 600_2200_M2 600_2200_M3 0.3
R_via_M2_M3_8_2 800_2200_M2 800_2200_M3 0.3
R_via_M2_M3_0_4 0_2400_M2 0_2400_M3 0.3
R_via_M2_M3_2_4 200_2400_M2 200_2400_M3 0.3
R_via_M2_M3_4_4 400_2400_M2 400_2400_M3 0.3
R_via_M2_M3_6_4 600_2400_M2 600_2400_M3 0.3
R_via_M2_M3_8_4 800_2400_M2 800_2400_M3 0.3
R_via_M2_M3_0_6 0_2600_M2 0_2600_M3 0.3
R_via_M2_M3_2_6 200_2600_M2 200_2600_M3 0.3
R_via_M2_M3_4_6 400_2600_M2 400_2600_M3 0.3
R_via_M2_M3_6_6 600_2600_M2 600_2600_M3 0.3
R_via_M2_M3_8_6 800_2600_M2 800_2600_M3 0.3
R_via_M2_M3_0_8 0_2800_M2 0_2800_M3 0.3
R_via_M2_M3_2_8 200_2800_M2 200_2800_M3 0.3
R_via_M2_M3_4_8 400_2800_M2 400_2800_M3 0.3
R_via_M2_M3_6_8 600_2800_M2 600_2800_M3 0.3
R_via_M2_M3_8_8 800_2800_M2 800_2800_M3 0.3

* ========== Decoupling capacitors ==========
C_decap_1_1 100_2100_M1 0 2e-13
C_decap_4_1 400_2100_M1 0 5e-14
C_decap_7_1 700_2100_M1 0 2e-13
C_decap_1_4 100_2400_M1 0 5e-14
C_decap_4_4 400_2400_M1 0 2e-13
C_decap_7_4 700_2400_M1 0 5e-14
C_decap_1_7 100_2700_M1 0 2e-13
C_decap_4_7 400_2700_M1 0 5e-14
C_decap_7_7 700_2700_M1 0 2e-13
* (9 decaps placed)

* ========== Boundary connections ==========
* Right boundary to tile_1_2
R_bnd_r_M1_0 *900_2000_M1 *1000_2000_M1 8
R_bnd_r_M2_0 *900_2000_M2 *1000_2000_M2 5
R_bnd_r_M3_0 *900_2000_M3 *1000_2000_M3 3
R_bnd_r_M1_1 *900_2100_M1 *1000_2100_M1 8
R_bnd_r_M2_1 *900_2100_M2 *1000_2100_M2 5
R_bnd_r_M3_1 *900_2100_M3 *1000_2100_M3 3
R_bnd_r_M1_2 *900_2200_M1 *1000_2200_M1 8
R_bnd_r_M2_2 *900_2200_M2 *1000_2200_M2 5
R_bnd_r_M3_2 *900_2200_M3 *1000_2200_M3 3
R_bnd_r_M1_3 *900_2300_M1 *1000_2300_M1 8
R_bnd_r_M2_3 *900_2300_M2 *1000_2300_M2 5
R_bnd_r_M3_3 *900_2300_M3 *1000_2300_M3 3
R_bnd_r_M1_4 *900_2400_M1 *1000_2400_M1 8
R_bnd_r_M2_4 *900_2400_M2 *1000_2400_M2 5
R_bnd_r_M3_4 *900_2400_M3 *1000_2400_M3 3
R_bnd_r_M1_5 *900_2500_M1 *1000_2500_M1 8
R_bnd_r_M2_5 *900_2500_M2 *1000_2500_M2 5
R_bnd_r_M3_5 *900_2500_M3 *1000_2500_M3 3
R_bnd_r_M1_6 *900_2600_M1 *1000_2600_M1 8
R_bnd_r_M2_6 *900_2600_M2 *1000_2600_M2 5
R_bnd_r_M3_6 *900_2600_M3 *1000_2600_M3 3
R_bnd_r_M1_7 *900_2700_M1 *1000_2700_M1 8
R_bnd_r_M2_7 *900_2700_M2 *1000_2700_M2 5
R_bnd_r_M3_7 *900_2700_M3 *1000_2700_M3 3
R_bnd_r_M1_8 *900_2800_M1 *1000_2800_M1 8
R_bnd_r_M2_8 *900_2800_M2 *1000_2800_M2 5
R_bnd_r_M3_8 *900_2800_M3 *1000_2800_M3 3
R_bnd_r_M1_9 *900_2900_M1 *1000_2900_M1 8
R_bnd_r_M2_9 *900_2900_M2 *1000_2900_M2 5
R_bnd_r_M3_9 *900_2900_M3 *1000_2900_M3 3

* Tile 0_2 summary: 620 R, 459 C
