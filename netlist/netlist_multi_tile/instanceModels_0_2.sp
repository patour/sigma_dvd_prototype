* Instance models for tile 0_2
* Current sources with static and dynamic currents
* Some nodes have multiple current sources (overlapping)

I_0_2_2_7 200_2700_M1 0 9.1591e-04
I_0_2_9_3 900_2300_M1 0 9.8882e-04 static_value=7.9252e-04
I_0_2_9_3_2 900_2300_M1 0 0 pulse(2.7011e-04, 2.5970e-03, 2.1985e-10, 4.4658e-10, 1.5272e-10, 3.0747e-09, 1.3519e-08)
I_0_2_1_9 100_2900_M1 0 0 pwl(0.0000e+00 8.0943e-04 1.3485e-09 1.3100e-04 3.8319e-09 1.3152e-03 6.3233e-09 1.1906e-03 8.8793e-09 1.2831e-03 1.0097e-08 1.2596e-03 1.2988e-08 1.0841e-04 1.5555e-08 2.1675e-03) pwl_period=1.9056e-08
I_0_2_8_3 800_2300_M1 0 4.8921e-04 pulse(0, 5.6083e-04, 0, 0.2n, 0.2n, 4.4369e-09, 1.4016e-08)
I_0_2_5_6 500_2600_M1 0 3.0583e-04 pwl(0 0 2n 7.4513e-04 5n 1.9097e-03 8n 3.3675e-04) pwl_period=10n
I_0_2_8_3_2 800_2300_M1 0 6.2119e-04
I_0_2_8_8 800_2800_M1 0 7.2581e-04 static_value=2.3941e-04
I_0_2_3_5 300_2500_M1 0 0 pulse(1.3751e-04, 2.2662e-03, 1.0967e-09, 2.3007e-10, 4.9785e-10, 3.5917e-09, 1.1176e-08)
I_0_2_5_3 500_2300_M1 0 0 pwl(0.0000e+00 1.0755e-03 2.5862e-09 2.8604e-04 4.8956e-09 2.1943e-03 6.9983e-09 2.1637e-03 8.8584e-09 2.2202e-03 1.0686e-08 2.0685e-03 1.2484e-08 1.8240e-03 1.4109e-08 7.8131e-04) pwl_period=1.7572e-08
I_0_2_1_2 100_2200_M1 0 4.0605e-04 pulse(0, 9.7427e-04, 0, 0.2n, 0.2n, 3.2737e-09, 1.0854e-08)
I_0_2_2_7_2 200_2700_M1 0 2.2956e-04 pwl(0 0 2n 8.7229e-04 5n 1.3726e-03 8n 3.6506e-04) pwl_period=10n
I_0_2_7_8 700_2800_M1 0 5.8997e-04
I_0_2_0_4 0_2400_M1 0 9.6964e-04 static_value=5.3701e-04
I_0_2_5_6_2 500_2600_M1 0 0 pulse(3.3501e-04, 1.8216e-03, 1.7472e-09, 4.7645e-10, 2.6917e-10, 4.7475e-09, 8.3601e-09)
I_0_2_1_2_2 100_2200_M1 0 0 pwl(0.0000e+00 1.5010e-03 1.7033e-09 1.4448e-03 3.1288e-09 1.6418e-03 4.5773e-09 2.7055e-04 7.2680e-09 9.1890e-04 9.7932e-09 1.4353e-03) pwl_period=1.4253e-08
I_0_2_5_2 500_2200_M1 0 4.9236e-04 pulse(0, 1.3184e-03, 0, 0.2n, 0.2n, 4.8407e-09, 1.6427e-08)
I_0_2_5_3_2 500_2300_M1 0 1.0788e-04 pwl(0 0 2n 9.6454e-04 5n 1.8295e-03 8n 4.3372e-04) pwl_period=10n
I_0_2_6_9 600_2900_M1 0 7.7062e-04
I_0_2_5_2_2 500_2200_M1 0 7.9189e-04 static_value=3.8539e-04
I_0_2_7_5 700_2500_M1 0 0 pulse(1.6991e-04, 1.0122e-03, 1.7397e-09, 3.2653e-10, 2.6031e-10, 2.4256e-09, 1.2432e-08)
I_0_2_4_7 400_2700_M1 0 0 pwl(0.0000e+00 2.2939e-04 2.0610e-09 9.4049e-04 3.9683e-09 3.9352e-04 5.5915e-09 8.1096e-04) pwl_period=1.0071e-08
I_0_2_9_5 900_2500_M1 0 4.6500e-04 pulse(0, 6.5558e-04, 0, 0.2n, 0.2n, 5.2633e-09, 1.0498e-08)
I_0_2_8_3_3 800_2300_M1 0 1.2447e-04 pwl(0 0 2n 7.2156e-04 5n 1.4240e-03 8n 6.0354e-04) pwl_period=10n
I_0_2_6_2 600_2200_M1 0 1.1213e-03

* Tile 0_2 summary:
*   Total current sources: 25
*   With static current: 17
*   With waveforms: 16
*   Overlapping nodes: 8
