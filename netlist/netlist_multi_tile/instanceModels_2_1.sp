* Instance models for tile 2_1
* Current sources with static and dynamic currents
* Some nodes have multiple current sources (overlapping)

I_2_1_5_8 2500_1800_M1 0 1.8551e-03
I_2_1_1_6 2100_1600_M1 0 3.3219e-04 static_value=6.7769e-04
I_2_1_1_2 2100_1200_M1 0 0 pulse(1.4668e-04, 1.7497e-03, 2.9114e-10, 3.1247e-10, 3.2637e-10, 4.3776e-09, 9.1899e-09)
I_2_1_4_9 2400_1900_M1 0 0 pwl(0.0000e+00 1.5237e-03 1.7651e-09 1.7078e-03 3.7604e-09 1.4579e-03 5.2248e-09 1.5948e-03) pwl_period=8.8108e-09
I_2_1_4_8 2400_1800_M1 0 4.6967e-04 pulse(0, 9.6525e-04, 0, 0.2n, 0.2n, 3.8629e-09, 1.5466e-08)
I_2_1_6_3 2600_1300_M1 0 1.2216e-04 pwl(0 0 2n 9.7262e-04 5n 1.9877e-03 8n 4.4958e-04) pwl_period=10n
I_2_1_6_4 2600_1400_M1 0 1.9430e-03
I_2_1_7_5 2700_1500_M1 0 7.8322e-04 static_value=4.7410e-04
I_2_1_0_4 2000_1400_M1 0 0 pulse(1.5106e-04, 2.9987e-03, 1.7067e-09, 1.4266e-10, 2.5255e-10, 3.0769e-09, 1.0071e-08)
I_2_1_9_2 2900_1200_M1 0 0 pwl(0.0000e+00 5.4849e-05 2.6601e-09 9.8951e-04 3.6763e-09 2.1627e-03 6.2329e-09 2.4340e-03 9.0541e-09 1.8629e-03 1.1720e-08 2.2573e-03) pwl_period=1.5501e-08
I_2_1_5_8_2 2500_1800_M1 0 4.4058e-04 pulse(0, 7.1900e-04, 0, 0.2n, 0.2n, 3.5704e-09, 1.2506e-08)
I_2_1_1_9 2100_1900_M1 0 3.2667e-04 pwl(0 0 2n 8.8374e-04 5n 1.6809e-03 8n 3.6839e-04) pwl_period=10n
I_2_1_6_7 2600_1700_M1 0 6.4575e-04
I_2_1_9_2_2 2900_1200_M1 0 7.3922e-04 static_value=2.2365e-04
I_2_1_8_3 2800_1300_M1 0 0 pulse(3.9431e-04, 1.0667e-03, 7.2972e-10, 1.5256e-10, 4.6385e-10, 2.9802e-09, 1.0909e-08)
I_2_1_0_4_2 2000_1400_M1 0 0 pwl(0.0000e+00 3.3040e-04 2.0788e-09 2.4287e-03 4.1405e-09 2.2837e-03 6.8015e-09 6.4243e-04 9.4508e-09 1.2046e-03) pwl_period=1.3810e-08
I_2_1_4_9_2 2400_1900_M1 0 3.0161e-04 pulse(0, 6.1517e-04, 0, 0.2n, 0.2n, 5.8887e-09, 1.1408e-08)
I_2_1_1_9_2 2100_1900_M1 0 3.8995e-04 pwl(0 0 2n 9.3007e-04 5n 1.7242e-03 8n 7.8997e-04) pwl_period=10n
I_2_1_0_1 2000_1100_M1 0 1.9509e-03
I_2_1_4_2 2400_1200_M1 0 8.6321e-04 static_value=4.1947e-04
I_2_1_5_6 2500_1600_M1 0 0 pulse(3.9534e-04, 1.0278e-03, 1.0731e-09, 2.8191e-10, 3.6913e-10, 4.0170e-09, 1.2092e-08)
I_2_1_8_4 2800_1400_M1 0 0 pwl(0.0000e+00 2.7087e-04 1.4676e-09 6.2562e-05 4.2361e-09 1.4035e-03 7.0666e-09 5.5342e-04 8.1931e-09 2.0596e-03 1.1012e-08 7.5548e-04) pwl_period=1.3968e-08
I_2_1_6_7_2 2600_1700_M1 0 4.8388e-04 pulse(0, 8.0436e-04, 0, 0.2n, 0.2n, 4.4779e-09, 1.0972e-08)
I_2_1_4_2_2 2400_1200_M1 0 3.6618e-04 pwl(0 0 2n 5.6783e-04 5n 1.4536e-03 8n 6.3524e-04) pwl_period=10n
I_2_1_8_4_2 2800_1400_M1 0 1.6147e-03

* Tile 2_1 summary:
*   Total current sources: 25
*   With static current: 17
*   With waveforms: 16
*   Overlapping nodes: 8
