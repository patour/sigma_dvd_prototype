* Tile 2_1 netlist
* Multi-layer routing with R, C elements
* Includes ground caps, coupling caps, and decaps

* ========== Layer M1 ==========
* Horizontal resistors (R=8 Ohm)
R_h_M1_0_0 2000_1000_M1 2100_1000_M1 8
R_h_M1_1_0 2100_1000_M1 2200_1000_M1 8
R_h_M1_2_0 2200_1000_M1 2300_1000_M1 8
R_h_M1_3_0 2300_1000_M1 2400_1000_M1 8
R_h_M1_4_0 2400_1000_M1 2500_1000_M1 8
R_h_M1_5_0 2500_1000_M1 2600_1000_M1 8
R_h_M1_6_0 2600_1000_M1 2700_1000_M1 8
R_h_M1_7_0 2700_1000_M1 2800_1000_M1 8
R_h_M1_8_0 2800_1000_M1 2900_1000_M1 8
R_h_M1_0_1 2000_1100_M1 2100_1100_M1 8
R_h_M1_1_1 2100_1100_M1 2200_1100_M1 8
R_h_M1_2_1 2200_1100_M1 2300_1100_M1 8
R_h_M1_3_1 2300_1100_M1 2400_1100_M1 8
R_h_M1_4_1 2400_1100_M1 2500_1100_M1 8
R_h_M1_5_1 2500_1100_M1 2600_1100_M1 8
R_h_M1_6_1 2600_1100_M1 2700_1100_M1 8
R_h_M1_7_1 2700_1100_M1 2800_1100_M1 8
R_h_M1_8_1 2800_1100_M1 2900_1100_M1 8
R_h_M1_0_2 2000_1200_M1 2100_1200_M1 8
R_h_M1_1_2 2100_1200_M1 2200_1200_M1 8
R_h_M1_2_2 2200_1200_M1 2300_1200_M1 8
R_h_M1_3_2 2300_1200_M1 2400_1200_M1 8
R_h_M1_4_2 2400_1200_M1 2500_1200_M1 8
R_h_M1_5_2 2500_1200_M1 2600_1200_M1 8
R_h_M1_6_2 2600_1200_M1 2700_1200_M1 8
R_h_M1_7_2 2700_1200_M1 2800_1200_M1 8
R_h_M1_8_2 2800_1200_M1 2900_1200_M1 8
R_h_M1_0_3 2000_1300_M1 2100_1300_M1 8
R_h_M1_1_3 2100_1300_M1 2200_1300_M1 8
R_h_M1_2_3 2200_1300_M1 2300_1300_M1 8
R_h_M1_3_3 2300_1300_M1 2400_1300_M1 8
R_h_M1_4_3 2400_1300_M1 2500_1300_M1 8
R_h_M1_5_3 2500_1300_M1 2600_1300_M1 8
R_h_M1_6_3 2600_1300_M1 2700_1300_M1 8
R_h_M1_7_3 2700_1300_M1 2800_1300_M1 8
R_h_M1_8_3 2800_1300_M1 2900_1300_M1 8
R_h_M1_0_4 2000_1400_M1 2100_1400_M1 8
R_h_M1_1_4 2100_1400_M1 2200_1400_M1 8
R_h_M1_2_4 2200_1400_M1 2300_1400_M1 8
R_h_M1_3_4 2300_1400_M1 2400_1400_M1 8
R_h_M1_4_4 2400_1400_M1 2500_1400_M1 8
R_h_M1_5_4 2500_1400_M1 2600_1400_M1 8
R_h_M1_6_4 2600_1400_M1 2700_1400_M1 8
R_h_M1_7_4 2700_1400_M1 2800_1400_M1 8
R_h_M1_8_4 2800_1400_M1 2900_1400_M1 8
R_h_M1_0_5 2000_1500_M1 2100_1500_M1 8
R_h_M1_1_5 2100_1500_M1 2200_1500_M1 8
R_h_M1_2_5 2200_1500_M1 2300_1500_M1 8
R_h_M1_3_5 2300_1500_M1 2400_1500_M1 8
R_h_M1_4_5 2400_1500_M1 2500_1500_M1 8
R_h_M1_5_5 2500_1500_M1 2600_1500_M1 8
R_h_M1_6_5 2600_1500_M1 2700_1500_M1 8
R_h_M1_7_5 2700_1500_M1 2800_1500_M1 8
R_h_M1_8_5 2800_1500_M1 2900_1500_M1 8
R_h_M1_0_6 2000_1600_M1 2100_1600_M1 8
R_h_M1_1_6 2100_1600_M1 2200_1600_M1 8
R_h_M1_2_6 2200_1600_M1 2300_1600_M1 8
R_h_M1_3_6 2300_1600_M1 2400_1600_M1 8
R_h_M1_4_6 2400_1600_M1 2500_1600_M1 8
R_h_M1_5_6 2500_1600_M1 2600_1600_M1 8
R_h_M1_6_6 2600_1600_M1 2700_1600_M1 8
R_h_M1_7_6 2700_1600_M1 2800_1600_M1 8
R_h_M1_8_6 2800_1600_M1 2900_1600_M1 8
R_h_M1_0_7 2000_1700_M1 2100_1700_M1 8
R_h_M1_1_7 2100_1700_M1 2200_1700_M1 8
R_h_M1_2_7 2200_1700_M1 2300_1700_M1 8
R_h_M1_3_7 2300_1700_M1 2400_1700_M1 8
R_h_M1_4_7 2400_1700_M1 2500_1700_M1 8
R_h_M1_5_7 2500_1700_M1 2600_1700_M1 8
R_h_M1_6_7 2600_1700_M1 2700_1700_M1 8
R_h_M1_7_7 2700_1700_M1 2800_1700_M1 8
R_h_M1_8_7 2800_1700_M1 2900_1700_M1 8
R_h_M1_0_8 2000_1800_M1 2100_1800_M1 8
R_h_M1_1_8 2100_1800_M1 2200_1800_M1 8
R_h_M1_2_8 2200_1800_M1 2300_1800_M1 8
R_h_M1_3_8 2300_1800_M1 2400_1800_M1 8
R_h_M1_4_8 2400_1800_M1 2500_1800_M1 8
R_h_M1_5_8 2500_1800_M1 2600_1800_M1 8
R_h_M1_6_8 2600_1800_M1 2700_1800_M1 8
R_h_M1_7_8 2700_1800_M1 2800_1800_M1 8
R_h_M1_8_8 2800_1800_M1 2900_1800_M1 8
R_h_M1_0_9 2000_1900_M1 2100_1900_M1 8
R_h_M1_1_9 2100_1900_M1 2200_1900_M1 8
R_h_M1_2_9 2200_1900_M1 2300_1900_M1 8
R_h_M1_3_9 2300_1900_M1 2400_1900_M1 8
R_h_M1_4_9 2400_1900_M1 2500_1900_M1 8
R_h_M1_5_9 2500_1900_M1 2600_1900_M1 8
R_h_M1_6_9 2600_1900_M1 2700_1900_M1 8
R_h_M1_7_9 2700_1900_M1 2800_1900_M1 8
R_h_M1_8_9 2800_1900_M1 2900_1900_M1 8
* Vertical resistors (R=10 Ohm)
R_v_M1_0_0 2000_1000_M1 2000_1100_M1 10
R_v_M1_1_0 2100_1000_M1 2100_1100_M1 10
R_v_M1_2_0 2200_1000_M1 2200_1100_M1 10
R_v_M1_3_0 2300_1000_M1 2300_1100_M1 10
R_v_M1_4_0 2400_1000_M1 2400_1100_M1 10
R_v_M1_5_0 2500_1000_M1 2500_1100_M1 10
R_v_M1_6_0 2600_1000_M1 2600_1100_M1 10
R_v_M1_7_0 2700_1000_M1 2700_1100_M1 10
R_v_M1_8_0 2800_1000_M1 2800_1100_M1 10
R_v_M1_9_0 2900_1000_M1 2900_1100_M1 10
R_v_M1_0_1 2000_1100_M1 2000_1200_M1 10
R_v_M1_1_1 2100_1100_M1 2100_1200_M1 10
R_v_M1_2_1 2200_1100_M1 2200_1200_M1 10
R_v_M1_3_1 2300_1100_M1 2300_1200_M1 10
R_v_M1_4_1 2400_1100_M1 2400_1200_M1 10
R_v_M1_5_1 2500_1100_M1 2500_1200_M1 10
R_v_M1_6_1 2600_1100_M1 2600_1200_M1 10
R_v_M1_7_1 2700_1100_M1 2700_1200_M1 10
R_v_M1_8_1 2800_1100_M1 2800_1200_M1 10
R_v_M1_9_1 2900_1100_M1 2900_1200_M1 10
R_v_M1_0_2 2000_1200_M1 2000_1300_M1 10
R_v_M1_1_2 2100_1200_M1 2100_1300_M1 10
R_v_M1_2_2 2200_1200_M1 2200_1300_M1 10
R_v_M1_3_2 2300_1200_M1 2300_1300_M1 10
R_v_M1_4_2 2400_1200_M1 2400_1300_M1 10
R_v_M1_5_2 2500_1200_M1 2500_1300_M1 10
R_v_M1_6_2 2600_1200_M1 2600_1300_M1 10
R_v_M1_7_2 2700_1200_M1 2700_1300_M1 10
R_v_M1_8_2 2800_1200_M1 2800_1300_M1 10
R_v_M1_9_2 2900_1200_M1 2900_1300_M1 10
R_v_M1_0_3 2000_1300_M1 2000_1400_M1 10
R_v_M1_1_3 2100_1300_M1 2100_1400_M1 10
R_v_M1_2_3 2200_1300_M1 2200_1400_M1 10
R_v_M1_3_3 2300_1300_M1 2300_1400_M1 10
R_v_M1_4_3 2400_1300_M1 2400_1400_M1 10
R_v_M1_5_3 2500_1300_M1 2500_1400_M1 10
R_v_M1_6_3 2600_1300_M1 2600_1400_M1 10
R_v_M1_7_3 2700_1300_M1 2700_1400_M1 10
R_v_M1_8_3 2800_1300_M1 2800_1400_M1 10
R_v_M1_9_3 2900_1300_M1 2900_1400_M1 10
R_v_M1_0_4 2000_1400_M1 2000_1500_M1 10
R_v_M1_1_4 2100_1400_M1 2100_1500_M1 10
R_v_M1_2_4 2200_1400_M1 2200_1500_M1 10
R_v_M1_3_4 2300_1400_M1 2300_1500_M1 10
R_v_M1_4_4 2400_1400_M1 2400_1500_M1 10
R_v_M1_5_4 2500_1400_M1 2500_1500_M1 10
R_v_M1_6_4 2600_1400_M1 2600_1500_M1 10
R_v_M1_7_4 2700_1400_M1 2700_1500_M1 10
R_v_M1_8_4 2800_1400_M1 2800_1500_M1 10
R_v_M1_9_4 2900_1400_M1 2900_1500_M1 10
R_v_M1_0_5 2000_1500_M1 2000_1600_M1 10
R_v_M1_1_5 2100_1500_M1 2100_1600_M1 10
R_v_M1_2_5 2200_1500_M1 2200_1600_M1 10
R_v_M1_3_5 2300_1500_M1 2300_1600_M1 10
R_v_M1_4_5 2400_1500_M1 2400_1600_M1 10
R_v_M1_5_5 2500_1500_M1 2500_1600_M1 10
R_v_M1_6_5 2600_1500_M1 2600_1600_M1 10
R_v_M1_7_5 2700_1500_M1 2700_1600_M1 10
R_v_M1_8_5 2800_1500_M1 2800_1600_M1 10
R_v_M1_9_5 2900_1500_M1 2900_1600_M1 10
R_v_M1_0_6 2000_1600_M1 2000_1700_M1 10
R_v_M1_1_6 2100_1600_M1 2100_1700_M1 10
R_v_M1_2_6 2200_1600_M1 2200_1700_M1 10
R_v_M1_3_6 2300_1600_M1 2300_1700_M1 10
R_v_M1_4_6 2400_1600_M1 2400_1700_M1 10
R_v_M1_5_6 2500_1600_M1 2500_1700_M1 10
R_v_M1_6_6 2600_1600_M1 2600_1700_M1 10
R_v_M1_7_6 2700_1600_M1 2700_1700_M1 10
R_v_M1_8_6 2800_1600_M1 2800_1700_M1 10
R_v_M1_9_6 2900_1600_M1 2900_1700_M1 10
R_v_M1_0_7 2000_1700_M1 2000_1800_M1 10
R_v_M1_1_7 2100_1700_M1 2100_1800_M1 10
R_v_M1_2_7 2200_1700_M1 2200_1800_M1 10
R_v_M1_3_7 2300_1700_M1 2300_1800_M1 10
R_v_M1_4_7 2400_1700_M1 2400_1800_M1 10
R_v_M1_5_7 2500_1700_M1 2500_1800_M1 10
R_v_M1_6_7 2600_1700_M1 2600_1800_M1 10
R_v_M1_7_7 2700_1700_M1 2700_1800_M1 10
R_v_M1_8_7 2800_1700_M1 2800_1800_M1 10
R_v_M1_9_7 2900_1700_M1 2900_1800_M1 10
R_v_M1_0_8 2000_1800_M1 2000_1900_M1 10
R_v_M1_1_8 2100_1800_M1 2100_1900_M1 10
R_v_M1_2_8 2200_1800_M1 2200_1900_M1 10
R_v_M1_3_8 2300_1800_M1 2300_1900_M1 10
R_v_M1_4_8 2400_1800_M1 2400_1900_M1 10
R_v_M1_5_8 2500_1800_M1 2500_1900_M1 10
R_v_M1_6_8 2600_1800_M1 2600_1900_M1 10
R_v_M1_7_8 2700_1800_M1 2700_1900_M1 10
R_v_M1_8_8 2800_1800_M1 2800_1900_M1 10
R_v_M1_9_8 2900_1800_M1 2900_1900_M1 10
* Ground capacitors (C=5.0 fF)
C_g_M1_0_0 2000_1000_M1 0 5e-15
C_g_M1_1_0 2100_1000_M1 0 5e-15
C_g_M1_2_0 2200_1000_M1 0 5e-15
C_g_M1_3_0 2300_1000_M1 0 5e-15
C_g_M1_4_0 2400_1000_M1 0 5e-15
C_g_M1_5_0 2500_1000_M1 0 5e-15
C_g_M1_6_0 2600_1000_M1 0 5e-15
C_g_M1_7_0 2700_1000_M1 0 5e-15
C_g_M1_8_0 2800_1000_M1 0 5e-15
C_g_M1_9_0 2900_1000_M1 0 5e-15
C_g_M1_0_1 2000_1100_M1 0 5e-15
C_g_M1_1_1 2100_1100_M1 0 5e-15
C_g_M1_2_1 2200_1100_M1 0 5e-15
C_g_M1_3_1 2300_1100_M1 0 5e-15
C_g_M1_4_1 2400_1100_M1 0 5e-15
C_g_M1_5_1 2500_1100_M1 0 5e-15
C_g_M1_6_1 2600_1100_M1 0 5e-15
C_g_M1_7_1 2700_1100_M1 0 5e-15
C_g_M1_8_1 2800_1100_M1 0 5e-15
C_g_M1_9_1 2900_1100_M1 0 5e-15
C_g_M1_0_2 2000_1200_M1 0 5e-15
C_g_M1_1_2 2100_1200_M1 0 5e-15
C_g_M1_2_2 2200_1200_M1 0 5e-15
C_g_M1_3_2 2300_1200_M1 0 5e-15
C_g_M1_4_2 2400_1200_M1 0 5e-15
C_g_M1_5_2 2500_1200_M1 0 5e-15
C_g_M1_6_2 2600_1200_M1 0 5e-15
C_g_M1_7_2 2700_1200_M1 0 5e-15
C_g_M1_8_2 2800_1200_M1 0 5e-15
C_g_M1_9_2 2900_1200_M1 0 5e-15
C_g_M1_0_3 2000_1300_M1 0 5e-15
C_g_M1_1_3 2100_1300_M1 0 5e-15
C_g_M1_2_3 2200_1300_M1 0 5e-15
C_g_M1_3_3 2300_1300_M1 0 5e-15
C_g_M1_4_3 2400_1300_M1 0 5e-15
C_g_M1_5_3 2500_1300_M1 0 5e-15
C_g_M1_6_3 2600_1300_M1 0 5e-15
C_g_M1_7_3 2700_1300_M1 0 5e-15
C_g_M1_8_3 2800_1300_M1 0 5e-15
C_g_M1_9_3 2900_1300_M1 0 5e-15
C_g_M1_0_4 2000_1400_M1 0 5e-15
C_g_M1_1_4 2100_1400_M1 0 5e-15
C_g_M1_2_4 2200_1400_M1 0 5e-15
C_g_M1_3_4 2300_1400_M1 0 5e-15
C_g_M1_4_4 2400_1400_M1 0 5e-15
C_g_M1_5_4 2500_1400_M1 0 5e-15
C_g_M1_6_4 2600_1400_M1 0 5e-15
C_g_M1_7_4 2700_1400_M1 0 5e-15
C_g_M1_8_4 2800_1400_M1 0 5e-15
C_g_M1_9_4 2900_1400_M1 0 5e-15
C_g_M1_0_5 2000_1500_M1 0 5e-15
C_g_M1_1_5 2100_1500_M1 0 5e-15
C_g_M1_2_5 2200_1500_M1 0 5e-15
C_g_M1_3_5 2300_1500_M1 0 5e-15
C_g_M1_4_5 2400_1500_M1 0 5e-15
C_g_M1_5_5 2500_1500_M1 0 5e-15
C_g_M1_6_5 2600_1500_M1 0 5e-15
C_g_M1_7_5 2700_1500_M1 0 5e-15
C_g_M1_8_5 2800_1500_M1 0 5e-15
C_g_M1_9_5 2900_1500_M1 0 5e-15
C_g_M1_0_6 2000_1600_M1 0 5e-15
C_g_M1_1_6 2100_1600_M1 0 5e-15
C_g_M1_2_6 2200_1600_M1 0 5e-15
C_g_M1_3_6 2300_1600_M1 0 5e-15
C_g_M1_4_6 2400_1600_M1 0 5e-15
C_g_M1_5_6 2500_1600_M1 0 5e-15
C_g_M1_6_6 2600_1600_M1 0 5e-15
C_g_M1_7_6 2700_1600_M1 0 5e-15
C_g_M1_8_6 2800_1600_M1 0 5e-15
C_g_M1_9_6 2900_1600_M1 0 5e-15
C_g_M1_0_7 2000_1700_M1 0 5e-15
C_g_M1_1_7 2100_1700_M1 0 5e-15
C_g_M1_2_7 2200_1700_M1 0 5e-15
C_g_M1_3_7 2300_1700_M1 0 5e-15
C_g_M1_4_7 2400_1700_M1 0 5e-15
C_g_M1_5_7 2500_1700_M1 0 5e-15
C_g_M1_6_7 2600_1700_M1 0 5e-15
C_g_M1_7_7 2700_1700_M1 0 5e-15
C_g_M1_8_7 2800_1700_M1 0 5e-15
C_g_M1_9_7 2900_1700_M1 0 5e-15
C_g_M1_0_8 2000_1800_M1 0 5e-15
C_g_M1_1_8 2100_1800_M1 0 5e-15
C_g_M1_2_8 2200_1800_M1 0 5e-15
C_g_M1_3_8 2300_1800_M1 0 5e-15
C_g_M1_4_8 2400_1800_M1 0 5e-15
C_g_M1_5_8 2500_1800_M1 0 5e-15
C_g_M1_6_8 2600_1800_M1 0 5e-15
C_g_M1_7_8 2700_1800_M1 0 5e-15
C_g_M1_8_8 2800_1800_M1 0 5e-15
C_g_M1_9_8 2900_1800_M1 0 5e-15
C_g_M1_0_9 2000_1900_M1 0 5e-15
C_g_M1_1_9 2100_1900_M1 0 5e-15
C_g_M1_2_9 2200_1900_M1 0 5e-15
C_g_M1_3_9 2300_1900_M1 0 5e-15
C_g_M1_4_9 2400_1900_M1 0 5e-15
C_g_M1_5_9 2500_1900_M1 0 5e-15
C_g_M1_6_9 2600_1900_M1 0 5e-15
C_g_M1_7_9 2700_1900_M1 0 5e-15
C_g_M1_8_9 2800_1900_M1 0 5e-15
C_g_M1_9_9 2900_1900_M1 0 5e-15
* Coupling capacitors (C=1.0 fF)
C_coup_M1_0_0 2000_1000_M1 2100_1000_M1 1e-15
C_coup_M1_2_0 2200_1000_M1 2300_1000_M1 1e-15
C_coup_M1_4_0 2400_1000_M1 2500_1000_M1 1e-15
C_coup_M1_6_0 2600_1000_M1 2700_1000_M1 1e-15
C_coup_M1_8_0 2800_1000_M1 2900_1000_M1 1e-15
C_coup_M1_0_1 2000_1100_M1 2100_1100_M1 1e-15
C_coup_M1_2_1 2200_1100_M1 2300_1100_M1 1e-15
C_coup_M1_4_1 2400_1100_M1 2500_1100_M1 1e-15
C_coup_M1_6_1 2600_1100_M1 2700_1100_M1 1e-15
C_coup_M1_8_1 2800_1100_M1 2900_1100_M1 1e-15
C_coup_M1_0_2 2000_1200_M1 2100_1200_M1 1e-15
C_coup_M1_2_2 2200_1200_M1 2300_1200_M1 1e-15
C_coup_M1_4_2 2400_1200_M1 2500_1200_M1 1e-15
C_coup_M1_6_2 2600_1200_M1 2700_1200_M1 1e-15
C_coup_M1_8_2 2800_1200_M1 2900_1200_M1 1e-15
C_coup_M1_0_3 2000_1300_M1 2100_1300_M1 1e-15
C_coup_M1_2_3 2200_1300_M1 2300_1300_M1 1e-15
C_coup_M1_4_3 2400_1300_M1 2500_1300_M1 1e-15
C_coup_M1_6_3 2600_1300_M1 2700_1300_M1 1e-15
C_coup_M1_8_3 2800_1300_M1 2900_1300_M1 1e-15
C_coup_M1_0_4 2000_1400_M1 2100_1400_M1 1e-15
C_coup_M1_2_4 2200_1400_M1 2300_1400_M1 1e-15
C_coup_M1_4_4 2400_1400_M1 2500_1400_M1 1e-15
C_coup_M1_6_4 2600_1400_M1 2700_1400_M1 1e-15
C_coup_M1_8_4 2800_1400_M1 2900_1400_M1 1e-15
C_coup_M1_0_5 2000_1500_M1 2100_1500_M1 1e-15
C_coup_M1_2_5 2200_1500_M1 2300_1500_M1 1e-15
C_coup_M1_4_5 2400_1500_M1 2500_1500_M1 1e-15
C_coup_M1_6_5 2600_1500_M1 2700_1500_M1 1e-15
C_coup_M1_8_5 2800_1500_M1 2900_1500_M1 1e-15
C_coup_M1_0_6 2000_1600_M1 2100_1600_M1 1e-15
C_coup_M1_2_6 2200_1600_M1 2300_1600_M1 1e-15
C_coup_M1_4_6 2400_1600_M1 2500_1600_M1 1e-15
C_coup_M1_6_6 2600_1600_M1 2700_1600_M1 1e-15
C_coup_M1_8_6 2800_1600_M1 2900_1600_M1 1e-15
C_coup_M1_0_7 2000_1700_M1 2100_1700_M1 1e-15
C_coup_M1_2_7 2200_1700_M1 2300_1700_M1 1e-15
C_coup_M1_4_7 2400_1700_M1 2500_1700_M1 1e-15
C_coup_M1_6_7 2600_1700_M1 2700_1700_M1 1e-15
C_coup_M1_8_7 2800_1700_M1 2900_1700_M1 1e-15
C_coup_M1_0_8 2000_1800_M1 2100_1800_M1 1e-15
C_coup_M1_2_8 2200_1800_M1 2300_1800_M1 1e-15
C_coup_M1_4_8 2400_1800_M1 2500_1800_M1 1e-15
C_coup_M1_6_8 2600_1800_M1 2700_1800_M1 1e-15
C_coup_M1_8_8 2800_1800_M1 2900_1800_M1 1e-15
C_coup_M1_0_9 2000_1900_M1 2100_1900_M1 1e-15
C_coup_M1_2_9 2200_1900_M1 2300_1900_M1 1e-15
C_coup_M1_4_9 2400_1900_M1 2500_1900_M1 1e-15
C_coup_M1_6_9 2600_1900_M1 2700_1900_M1 1e-15
C_coup_M1_8_9 2800_1900_M1 2900_1900_M1 1e-15

* ========== Layer M2 ==========
* Horizontal resistors (R=5 Ohm)
R_h_M2_0_0 2000_1000_M2 2100_1000_M2 5
R_h_M2_1_0 2100_1000_M2 2200_1000_M2 5
R_h_M2_2_0 2200_1000_M2 2300_1000_M2 5
R_h_M2_3_0 2300_1000_M2 2400_1000_M2 5
R_h_M2_4_0 2400_1000_M2 2500_1000_M2 5
R_h_M2_5_0 2500_1000_M2 2600_1000_M2 5
R_h_M2_6_0 2600_1000_M2 2700_1000_M2 5
R_h_M2_7_0 2700_1000_M2 2800_1000_M2 5
R_h_M2_8_0 2800_1000_M2 2900_1000_M2 5
R_h_M2_0_1 2000_1100_M2 2100_1100_M2 5
R_h_M2_1_1 2100_1100_M2 2200_1100_M2 5
R_h_M2_2_1 2200_1100_M2 2300_1100_M2 5
R_h_M2_3_1 2300_1100_M2 2400_1100_M2 5
R_h_M2_4_1 2400_1100_M2 2500_1100_M2 5
R_h_M2_5_1 2500_1100_M2 2600_1100_M2 5
R_h_M2_6_1 2600_1100_M2 2700_1100_M2 5
R_h_M2_7_1 2700_1100_M2 2800_1100_M2 5
R_h_M2_8_1 2800_1100_M2 2900_1100_M2 5
R_h_M2_0_2 2000_1200_M2 2100_1200_M2 5
R_h_M2_1_2 2100_1200_M2 2200_1200_M2 5
R_h_M2_2_2 2200_1200_M2 2300_1200_M2 5
R_h_M2_3_2 2300_1200_M2 2400_1200_M2 5
R_h_M2_4_2 2400_1200_M2 2500_1200_M2 5
R_h_M2_5_2 2500_1200_M2 2600_1200_M2 5
R_h_M2_6_2 2600_1200_M2 2700_1200_M2 5
R_h_M2_7_2 2700_1200_M2 2800_1200_M2 5
R_h_M2_8_2 2800_1200_M2 2900_1200_M2 5
R_h_M2_0_3 2000_1300_M2 2100_1300_M2 5
R_h_M2_1_3 2100_1300_M2 2200_1300_M2 5
R_h_M2_2_3 2200_1300_M2 2300_1300_M2 5
R_h_M2_3_3 2300_1300_M2 2400_1300_M2 5
R_h_M2_4_3 2400_1300_M2 2500_1300_M2 5
R_h_M2_5_3 2500_1300_M2 2600_1300_M2 5
R_h_M2_6_3 2600_1300_M2 2700_1300_M2 5
R_h_M2_7_3 2700_1300_M2 2800_1300_M2 5
R_h_M2_8_3 2800_1300_M2 2900_1300_M2 5
R_h_M2_0_4 2000_1400_M2 2100_1400_M2 5
R_h_M2_1_4 2100_1400_M2 2200_1400_M2 5
R_h_M2_2_4 2200_1400_M2 2300_1400_M2 5
R_h_M2_3_4 2300_1400_M2 2400_1400_M2 5
R_h_M2_4_4 2400_1400_M2 2500_1400_M2 5
R_h_M2_5_4 2500_1400_M2 2600_1400_M2 5
R_h_M2_6_4 2600_1400_M2 2700_1400_M2 5
R_h_M2_7_4 2700_1400_M2 2800_1400_M2 5
R_h_M2_8_4 2800_1400_M2 2900_1400_M2 5
R_h_M2_0_5 2000_1500_M2 2100_1500_M2 5
R_h_M2_1_5 2100_1500_M2 2200_1500_M2 5
R_h_M2_2_5 2200_1500_M2 2300_1500_M2 5
R_h_M2_3_5 2300_1500_M2 2400_1500_M2 5
R_h_M2_4_5 2400_1500_M2 2500_1500_M2 5
R_h_M2_5_5 2500_1500_M2 2600_1500_M2 5
R_h_M2_6_5 2600_1500_M2 2700_1500_M2 5
R_h_M2_7_5 2700_1500_M2 2800_1500_M2 5
R_h_M2_8_5 2800_1500_M2 2900_1500_M2 5
R_h_M2_0_6 2000_1600_M2 2100_1600_M2 5
R_h_M2_1_6 2100_1600_M2 2200_1600_M2 5
R_h_M2_2_6 2200_1600_M2 2300_1600_M2 5
R_h_M2_3_6 2300_1600_M2 2400_1600_M2 5
R_h_M2_4_6 2400_1600_M2 2500_1600_M2 5
R_h_M2_5_6 2500_1600_M2 2600_1600_M2 5
R_h_M2_6_6 2600_1600_M2 2700_1600_M2 5
R_h_M2_7_6 2700_1600_M2 2800_1600_M2 5
R_h_M2_8_6 2800_1600_M2 2900_1600_M2 5
R_h_M2_0_7 2000_1700_M2 2100_1700_M2 5
R_h_M2_1_7 2100_1700_M2 2200_1700_M2 5
R_h_M2_2_7 2200_1700_M2 2300_1700_M2 5
R_h_M2_3_7 2300_1700_M2 2400_1700_M2 5
R_h_M2_4_7 2400_1700_M2 2500_1700_M2 5
R_h_M2_5_7 2500_1700_M2 2600_1700_M2 5
R_h_M2_6_7 2600_1700_M2 2700_1700_M2 5
R_h_M2_7_7 2700_1700_M2 2800_1700_M2 5
R_h_M2_8_7 2800_1700_M2 2900_1700_M2 5
R_h_M2_0_8 2000_1800_M2 2100_1800_M2 5
R_h_M2_1_8 2100_1800_M2 2200_1800_M2 5
R_h_M2_2_8 2200_1800_M2 2300_1800_M2 5
R_h_M2_3_8 2300_1800_M2 2400_1800_M2 5
R_h_M2_4_8 2400_1800_M2 2500_1800_M2 5
R_h_M2_5_8 2500_1800_M2 2600_1800_M2 5
R_h_M2_6_8 2600_1800_M2 2700_1800_M2 5
R_h_M2_7_8 2700_1800_M2 2800_1800_M2 5
R_h_M2_8_8 2800_1800_M2 2900_1800_M2 5
R_h_M2_0_9 2000_1900_M2 2100_1900_M2 5
R_h_M2_1_9 2100_1900_M2 2200_1900_M2 5
R_h_M2_2_9 2200_1900_M2 2300_1900_M2 5
R_h_M2_3_9 2300_1900_M2 2400_1900_M2 5
R_h_M2_4_9 2400_1900_M2 2500_1900_M2 5
R_h_M2_5_9 2500_1900_M2 2600_1900_M2 5
R_h_M2_6_9 2600_1900_M2 2700_1900_M2 5
R_h_M2_7_9 2700_1900_M2 2800_1900_M2 5
R_h_M2_8_9 2800_1900_M2 2900_1900_M2 5
* Vertical resistors (R=6 Ohm)
R_v_M2_0_0 2000_1000_M2 2000_1100_M2 6
R_v_M2_1_0 2100_1000_M2 2100_1100_M2 6
R_v_M2_2_0 2200_1000_M2 2200_1100_M2 6
R_v_M2_3_0 2300_1000_M2 2300_1100_M2 6
R_v_M2_4_0 2400_1000_M2 2400_1100_M2 6
R_v_M2_5_0 2500_1000_M2 2500_1100_M2 6
R_v_M2_6_0 2600_1000_M2 2600_1100_M2 6
R_v_M2_7_0 2700_1000_M2 2700_1100_M2 6
R_v_M2_8_0 2800_1000_M2 2800_1100_M2 6
R_v_M2_9_0 2900_1000_M2 2900_1100_M2 6
R_v_M2_0_1 2000_1100_M2 2000_1200_M2 6
R_v_M2_1_1 2100_1100_M2 2100_1200_M2 6
R_v_M2_2_1 2200_1100_M2 2200_1200_M2 6
R_v_M2_3_1 2300_1100_M2 2300_1200_M2 6
R_v_M2_4_1 2400_1100_M2 2400_1200_M2 6
R_v_M2_5_1 2500_1100_M2 2500_1200_M2 6
R_v_M2_6_1 2600_1100_M2 2600_1200_M2 6
R_v_M2_7_1 2700_1100_M2 2700_1200_M2 6
R_v_M2_8_1 2800_1100_M2 2800_1200_M2 6
R_v_M2_9_1 2900_1100_M2 2900_1200_M2 6
R_v_M2_0_2 2000_1200_M2 2000_1300_M2 6
R_v_M2_1_2 2100_1200_M2 2100_1300_M2 6
R_v_M2_2_2 2200_1200_M2 2200_1300_M2 6
R_v_M2_3_2 2300_1200_M2 2300_1300_M2 6
R_v_M2_4_2 2400_1200_M2 2400_1300_M2 6
R_v_M2_5_2 2500_1200_M2 2500_1300_M2 6
R_v_M2_6_2 2600_1200_M2 2600_1300_M2 6
R_v_M2_7_2 2700_1200_M2 2700_1300_M2 6
R_v_M2_8_2 2800_1200_M2 2800_1300_M2 6
R_v_M2_9_2 2900_1200_M2 2900_1300_M2 6
R_v_M2_0_3 2000_1300_M2 2000_1400_M2 6
R_v_M2_1_3 2100_1300_M2 2100_1400_M2 6
R_v_M2_2_3 2200_1300_M2 2200_1400_M2 6
R_v_M2_3_3 2300_1300_M2 2300_1400_M2 6
R_v_M2_4_3 2400_1300_M2 2400_1400_M2 6
R_v_M2_5_3 2500_1300_M2 2500_1400_M2 6
R_v_M2_6_3 2600_1300_M2 2600_1400_M2 6
R_v_M2_7_3 2700_1300_M2 2700_1400_M2 6
R_v_M2_8_3 2800_1300_M2 2800_1400_M2 6
R_v_M2_9_3 2900_1300_M2 2900_1400_M2 6
R_v_M2_0_4 2000_1400_M2 2000_1500_M2 6
R_v_M2_1_4 2100_1400_M2 2100_1500_M2 6
R_v_M2_2_4 2200_1400_M2 2200_1500_M2 6
R_v_M2_3_4 2300_1400_M2 2300_1500_M2 6
R_v_M2_4_4 2400_1400_M2 2400_1500_M2 6
R_v_M2_5_4 2500_1400_M2 2500_1500_M2 6
R_v_M2_6_4 2600_1400_M2 2600_1500_M2 6
R_v_M2_7_4 2700_1400_M2 2700_1500_M2 6
R_v_M2_8_4 2800_1400_M2 2800_1500_M2 6
R_v_M2_9_4 2900_1400_M2 2900_1500_M2 6
R_v_M2_0_5 2000_1500_M2 2000_1600_M2 6
R_v_M2_1_5 2100_1500_M2 2100_1600_M2 6
R_v_M2_2_5 2200_1500_M2 2200_1600_M2 6
R_v_M2_3_5 2300_1500_M2 2300_1600_M2 6
R_v_M2_4_5 2400_1500_M2 2400_1600_M2 6
R_v_M2_5_5 2500_1500_M2 2500_1600_M2 6
R_v_M2_6_5 2600_1500_M2 2600_1600_M2 6
R_v_M2_7_5 2700_1500_M2 2700_1600_M2 6
R_v_M2_8_5 2800_1500_M2 2800_1600_M2 6
R_v_M2_9_5 2900_1500_M2 2900_1600_M2 6
R_v_M2_0_6 2000_1600_M2 2000_1700_M2 6
R_v_M2_1_6 2100_1600_M2 2100_1700_M2 6
R_v_M2_2_6 2200_1600_M2 2200_1700_M2 6
R_v_M2_3_6 2300_1600_M2 2300_1700_M2 6
R_v_M2_4_6 2400_1600_M2 2400_1700_M2 6
R_v_M2_5_6 2500_1600_M2 2500_1700_M2 6
R_v_M2_6_6 2600_1600_M2 2600_1700_M2 6
R_v_M2_7_6 2700_1600_M2 2700_1700_M2 6
R_v_M2_8_6 2800_1600_M2 2800_1700_M2 6
R_v_M2_9_6 2900_1600_M2 2900_1700_M2 6
R_v_M2_0_7 2000_1700_M2 2000_1800_M2 6
R_v_M2_1_7 2100_1700_M2 2100_1800_M2 6
R_v_M2_2_7 2200_1700_M2 2200_1800_M2 6
R_v_M2_3_7 2300_1700_M2 2300_1800_M2 6
R_v_M2_4_7 2400_1700_M2 2400_1800_M2 6
R_v_M2_5_7 2500_1700_M2 2500_1800_M2 6
R_v_M2_6_7 2600_1700_M2 2600_1800_M2 6
R_v_M2_7_7 2700_1700_M2 2700_1800_M2 6
R_v_M2_8_7 2800_1700_M2 2800_1800_M2 6
R_v_M2_9_7 2900_1700_M2 2900_1800_M2 6
R_v_M2_0_8 2000_1800_M2 2000_1900_M2 6
R_v_M2_1_8 2100_1800_M2 2100_1900_M2 6
R_v_M2_2_8 2200_1800_M2 2200_1900_M2 6
R_v_M2_3_8 2300_1800_M2 2300_1900_M2 6
R_v_M2_4_8 2400_1800_M2 2400_1900_M2 6
R_v_M2_5_8 2500_1800_M2 2500_1900_M2 6
R_v_M2_6_8 2600_1800_M2 2600_1900_M2 6
R_v_M2_7_8 2700_1800_M2 2700_1900_M2 6
R_v_M2_8_8 2800_1800_M2 2800_1900_M2 6
R_v_M2_9_8 2900_1800_M2 2900_1900_M2 6
* Ground capacitors (C=3.0 fF)
C_g_M2_0_0 2000_1000_M2 0 3e-15
C_g_M2_1_0 2100_1000_M2 0 3e-15
C_g_M2_2_0 2200_1000_M2 0 3e-15
C_g_M2_3_0 2300_1000_M2 0 3e-15
C_g_M2_4_0 2400_1000_M2 0 3e-15
C_g_M2_5_0 2500_1000_M2 0 3e-15
C_g_M2_6_0 2600_1000_M2 0 3e-15
C_g_M2_7_0 2700_1000_M2 0 3e-15
C_g_M2_8_0 2800_1000_M2 0 3e-15
C_g_M2_9_0 2900_1000_M2 0 3e-15
C_g_M2_0_1 2000_1100_M2 0 3e-15
C_g_M2_1_1 2100_1100_M2 0 3e-15
C_g_M2_2_1 2200_1100_M2 0 3e-15
C_g_M2_3_1 2300_1100_M2 0 3e-15
C_g_M2_4_1 2400_1100_M2 0 3e-15
C_g_M2_5_1 2500_1100_M2 0 3e-15
C_g_M2_6_1 2600_1100_M2 0 3e-15
C_g_M2_7_1 2700_1100_M2 0 3e-15
C_g_M2_8_1 2800_1100_M2 0 3e-15
C_g_M2_9_1 2900_1100_M2 0 3e-15
C_g_M2_0_2 2000_1200_M2 0 3e-15
C_g_M2_1_2 2100_1200_M2 0 3e-15
C_g_M2_2_2 2200_1200_M2 0 3e-15
C_g_M2_3_2 2300_1200_M2 0 3e-15
C_g_M2_4_2 2400_1200_M2 0 3e-15
C_g_M2_5_2 2500_1200_M2 0 3e-15
C_g_M2_6_2 2600_1200_M2 0 3e-15
C_g_M2_7_2 2700_1200_M2 0 3e-15
C_g_M2_8_2 2800_1200_M2 0 3e-15
C_g_M2_9_2 2900_1200_M2 0 3e-15
C_g_M2_0_3 2000_1300_M2 0 3e-15
C_g_M2_1_3 2100_1300_M2 0 3e-15
C_g_M2_2_3 2200_1300_M2 0 3e-15
C_g_M2_3_3 2300_1300_M2 0 3e-15
C_g_M2_4_3 2400_1300_M2 0 3e-15
C_g_M2_5_3 2500_1300_M2 0 3e-15
C_g_M2_6_3 2600_1300_M2 0 3e-15
C_g_M2_7_3 2700_1300_M2 0 3e-15
C_g_M2_8_3 2800_1300_M2 0 3e-15
C_g_M2_9_3 2900_1300_M2 0 3e-15
C_g_M2_0_4 2000_1400_M2 0 3e-15
C_g_M2_1_4 2100_1400_M2 0 3e-15
C_g_M2_2_4 2200_1400_M2 0 3e-15
C_g_M2_3_4 2300_1400_M2 0 3e-15
C_g_M2_4_4 2400_1400_M2 0 3e-15
C_g_M2_5_4 2500_1400_M2 0 3e-15
C_g_M2_6_4 2600_1400_M2 0 3e-15
C_g_M2_7_4 2700_1400_M2 0 3e-15
C_g_M2_8_4 2800_1400_M2 0 3e-15
C_g_M2_9_4 2900_1400_M2 0 3e-15
C_g_M2_0_5 2000_1500_M2 0 3e-15
C_g_M2_1_5 2100_1500_M2 0 3e-15
C_g_M2_2_5 2200_1500_M2 0 3e-15
C_g_M2_3_5 2300_1500_M2 0 3e-15
C_g_M2_4_5 2400_1500_M2 0 3e-15
C_g_M2_5_5 2500_1500_M2 0 3e-15
C_g_M2_6_5 2600_1500_M2 0 3e-15
C_g_M2_7_5 2700_1500_M2 0 3e-15
C_g_M2_8_5 2800_1500_M2 0 3e-15
C_g_M2_9_5 2900_1500_M2 0 3e-15
C_g_M2_0_6 2000_1600_M2 0 3e-15
C_g_M2_1_6 2100_1600_M2 0 3e-15
C_g_M2_2_6 2200_1600_M2 0 3e-15
C_g_M2_3_6 2300_1600_M2 0 3e-15
C_g_M2_4_6 2400_1600_M2 0 3e-15
C_g_M2_5_6 2500_1600_M2 0 3e-15
C_g_M2_6_6 2600_1600_M2 0 3e-15
C_g_M2_7_6 2700_1600_M2 0 3e-15
C_g_M2_8_6 2800_1600_M2 0 3e-15
C_g_M2_9_6 2900_1600_M2 0 3e-15
C_g_M2_0_7 2000_1700_M2 0 3e-15
C_g_M2_1_7 2100_1700_M2 0 3e-15
C_g_M2_2_7 2200_1700_M2 0 3e-15
C_g_M2_3_7 2300_1700_M2 0 3e-15
C_g_M2_4_7 2400_1700_M2 0 3e-15
C_g_M2_5_7 2500_1700_M2 0 3e-15
C_g_M2_6_7 2600_1700_M2 0 3e-15
C_g_M2_7_7 2700_1700_M2 0 3e-15
C_g_M2_8_7 2800_1700_M2 0 3e-15
C_g_M2_9_7 2900_1700_M2 0 3e-15
C_g_M2_0_8 2000_1800_M2 0 3e-15
C_g_M2_1_8 2100_1800_M2 0 3e-15
C_g_M2_2_8 2200_1800_M2 0 3e-15
C_g_M2_3_8 2300_1800_M2 0 3e-15
C_g_M2_4_8 2400_1800_M2 0 3e-15
C_g_M2_5_8 2500_1800_M2 0 3e-15
C_g_M2_6_8 2600_1800_M2 0 3e-15
C_g_M2_7_8 2700_1800_M2 0 3e-15
C_g_M2_8_8 2800_1800_M2 0 3e-15
C_g_M2_9_8 2900_1800_M2 0 3e-15
C_g_M2_0_9 2000_1900_M2 0 3e-15
C_g_M2_1_9 2100_1900_M2 0 3e-15
C_g_M2_2_9 2200_1900_M2 0 3e-15
C_g_M2_3_9 2300_1900_M2 0 3e-15
C_g_M2_4_9 2400_1900_M2 0 3e-15
C_g_M2_5_9 2500_1900_M2 0 3e-15
C_g_M2_6_9 2600_1900_M2 0 3e-15
C_g_M2_7_9 2700_1900_M2 0 3e-15
C_g_M2_8_9 2800_1900_M2 0 3e-15
C_g_M2_9_9 2900_1900_M2 0 3e-15
* Coupling capacitors (C=1.0 fF)
C_coup_M2_0_0 2000_1000_M2 2100_1000_M2 1e-15
C_coup_M2_2_0 2200_1000_M2 2300_1000_M2 1e-15
C_coup_M2_4_0 2400_1000_M2 2500_1000_M2 1e-15
C_coup_M2_6_0 2600_1000_M2 2700_1000_M2 1e-15
C_coup_M2_8_0 2800_1000_M2 2900_1000_M2 1e-15
C_coup_M2_0_1 2000_1100_M2 2100_1100_M2 1e-15
C_coup_M2_2_1 2200_1100_M2 2300_1100_M2 1e-15
C_coup_M2_4_1 2400_1100_M2 2500_1100_M2 1e-15
C_coup_M2_6_1 2600_1100_M2 2700_1100_M2 1e-15
C_coup_M2_8_1 2800_1100_M2 2900_1100_M2 1e-15
C_coup_M2_0_2 2000_1200_M2 2100_1200_M2 1e-15
C_coup_M2_2_2 2200_1200_M2 2300_1200_M2 1e-15
C_coup_M2_4_2 2400_1200_M2 2500_1200_M2 1e-15
C_coup_M2_6_2 2600_1200_M2 2700_1200_M2 1e-15
C_coup_M2_8_2 2800_1200_M2 2900_1200_M2 1e-15
C_coup_M2_0_3 2000_1300_M2 2100_1300_M2 1e-15
C_coup_M2_2_3 2200_1300_M2 2300_1300_M2 1e-15
C_coup_M2_4_3 2400_1300_M2 2500_1300_M2 1e-15
C_coup_M2_6_3 2600_1300_M2 2700_1300_M2 1e-15
C_coup_M2_8_3 2800_1300_M2 2900_1300_M2 1e-15
C_coup_M2_0_4 2000_1400_M2 2100_1400_M2 1e-15
C_coup_M2_2_4 2200_1400_M2 2300_1400_M2 1e-15
C_coup_M2_4_4 2400_1400_M2 2500_1400_M2 1e-15
C_coup_M2_6_4 2600_1400_M2 2700_1400_M2 1e-15
C_coup_M2_8_4 2800_1400_M2 2900_1400_M2 1e-15
C_coup_M2_0_5 2000_1500_M2 2100_1500_M2 1e-15
C_coup_M2_2_5 2200_1500_M2 2300_1500_M2 1e-15
C_coup_M2_4_5 2400_1500_M2 2500_1500_M2 1e-15
C_coup_M2_6_5 2600_1500_M2 2700_1500_M2 1e-15
C_coup_M2_8_5 2800_1500_M2 2900_1500_M2 1e-15
C_coup_M2_0_6 2000_1600_M2 2100_1600_M2 1e-15
C_coup_M2_2_6 2200_1600_M2 2300_1600_M2 1e-15
C_coup_M2_4_6 2400_1600_M2 2500_1600_M2 1e-15
C_coup_M2_6_6 2600_1600_M2 2700_1600_M2 1e-15
C_coup_M2_8_6 2800_1600_M2 2900_1600_M2 1e-15
C_coup_M2_0_7 2000_1700_M2 2100_1700_M2 1e-15
C_coup_M2_2_7 2200_1700_M2 2300_1700_M2 1e-15
C_coup_M2_4_7 2400_1700_M2 2500_1700_M2 1e-15
C_coup_M2_6_7 2600_1700_M2 2700_1700_M2 1e-15
C_coup_M2_8_7 2800_1700_M2 2900_1700_M2 1e-15
C_coup_M2_0_8 2000_1800_M2 2100_1800_M2 1e-15
C_coup_M2_2_8 2200_1800_M2 2300_1800_M2 1e-15
C_coup_M2_4_8 2400_1800_M2 2500_1800_M2 1e-15
C_coup_M2_6_8 2600_1800_M2 2700_1800_M2 1e-15
C_coup_M2_8_8 2800_1800_M2 2900_1800_M2 1e-15
C_coup_M2_0_9 2000_1900_M2 2100_1900_M2 1e-15
C_coup_M2_2_9 2200_1900_M2 2300_1900_M2 1e-15
C_coup_M2_4_9 2400_1900_M2 2500_1900_M2 1e-15
C_coup_M2_6_9 2600_1900_M2 2700_1900_M2 1e-15
C_coup_M2_8_9 2800_1900_M2 2900_1900_M2 1e-15

* ========== Layer M3 ==========
* Horizontal resistors (R=3 Ohm)
R_h_M3_0_0 2000_1000_M3 2100_1000_M3 3
R_h_M3_1_0 2100_1000_M3 2200_1000_M3 3
R_h_M3_2_0 2200_1000_M3 2300_1000_M3 3
R_h_M3_3_0 2300_1000_M3 2400_1000_M3 3
R_h_M3_4_0 2400_1000_M3 2500_1000_M3 3
R_h_M3_5_0 2500_1000_M3 2600_1000_M3 3
R_h_M3_6_0 2600_1000_M3 2700_1000_M3 3
R_h_M3_7_0 2700_1000_M3 2800_1000_M3 3
R_h_M3_8_0 2800_1000_M3 2900_1000_M3 3
R_h_M3_0_1 2000_1100_M3 2100_1100_M3 3
R_h_M3_1_1 2100_1100_M3 2200_1100_M3 3
R_h_M3_2_1 2200_1100_M3 2300_1100_M3 3
R_h_M3_3_1 2300_1100_M3 2400_1100_M3 3
R_h_M3_4_1 2400_1100_M3 2500_1100_M3 3
R_h_M3_5_1 2500_1100_M3 2600_1100_M3 3
R_h_M3_6_1 2600_1100_M3 2700_1100_M3 3
R_h_M3_7_1 2700_1100_M3 2800_1100_M3 3
R_h_M3_8_1 2800_1100_M3 2900_1100_M3 3
R_h_M3_0_2 2000_1200_M3 2100_1200_M3 3
R_h_M3_1_2 2100_1200_M3 2200_1200_M3 3
R_h_M3_2_2 2200_1200_M3 2300_1200_M3 3
R_h_M3_3_2 2300_1200_M3 2400_1200_M3 3
R_h_M3_4_2 2400_1200_M3 2500_1200_M3 3
R_h_M3_5_2 2500_1200_M3 2600_1200_M3 3
R_h_M3_6_2 2600_1200_M3 2700_1200_M3 3
R_h_M3_7_2 2700_1200_M3 2800_1200_M3 3
R_h_M3_8_2 2800_1200_M3 2900_1200_M3 3
R_h_M3_0_3 2000_1300_M3 2100_1300_M3 3
R_h_M3_1_3 2100_1300_M3 2200_1300_M3 3
R_h_M3_2_3 2200_1300_M3 2300_1300_M3 3
R_h_M3_3_3 2300_1300_M3 2400_1300_M3 3
R_h_M3_4_3 2400_1300_M3 2500_1300_M3 3
R_h_M3_5_3 2500_1300_M3 2600_1300_M3 3
R_h_M3_6_3 2600_1300_M3 2700_1300_M3 3
R_h_M3_7_3 2700_1300_M3 2800_1300_M3 3
R_h_M3_8_3 2800_1300_M3 2900_1300_M3 3
R_h_M3_0_4 2000_1400_M3 2100_1400_M3 3
R_h_M3_1_4 2100_1400_M3 2200_1400_M3 3
R_h_M3_2_4 2200_1400_M3 2300_1400_M3 3
R_h_M3_3_4 2300_1400_M3 2400_1400_M3 3
R_h_M3_4_4 2400_1400_M3 2500_1400_M3 3
R_h_M3_5_4 2500_1400_M3 2600_1400_M3 3
R_h_M3_6_4 2600_1400_M3 2700_1400_M3 3
R_h_M3_7_4 2700_1400_M3 2800_1400_M3 3
R_h_M3_8_4 2800_1400_M3 2900_1400_M3 3
R_h_M3_0_5 2000_1500_M3 2100_1500_M3 3
R_h_M3_1_5 2100_1500_M3 2200_1500_M3 3
R_h_M3_2_5 2200_1500_M3 2300_1500_M3 3
R_h_M3_3_5 2300_1500_M3 2400_1500_M3 3
R_h_M3_4_5 2400_1500_M3 2500_1500_M3 3
R_h_M3_5_5 2500_1500_M3 2600_1500_M3 3
R_h_M3_6_5 2600_1500_M3 2700_1500_M3 3
R_h_M3_7_5 2700_1500_M3 2800_1500_M3 3
R_h_M3_8_5 2800_1500_M3 2900_1500_M3 3
R_h_M3_0_6 2000_1600_M3 2100_1600_M3 3
R_h_M3_1_6 2100_1600_M3 2200_1600_M3 3
R_h_M3_2_6 2200_1600_M3 2300_1600_M3 3
R_h_M3_3_6 2300_1600_M3 2400_1600_M3 3
R_h_M3_4_6 2400_1600_M3 2500_1600_M3 3
R_h_M3_5_6 2500_1600_M3 2600_1600_M3 3
R_h_M3_6_6 2600_1600_M3 2700_1600_M3 3
R_h_M3_7_6 2700_1600_M3 2800_1600_M3 3
R_h_M3_8_6 2800_1600_M3 2900_1600_M3 3
R_h_M3_0_7 2000_1700_M3 2100_1700_M3 3
R_h_M3_1_7 2100_1700_M3 2200_1700_M3 3
R_h_M3_2_7 2200_1700_M3 2300_1700_M3 3
R_h_M3_3_7 2300_1700_M3 2400_1700_M3 3
R_h_M3_4_7 2400_1700_M3 2500_1700_M3 3
R_h_M3_5_7 2500_1700_M3 2600_1700_M3 3
R_h_M3_6_7 2600_1700_M3 2700_1700_M3 3
R_h_M3_7_7 2700_1700_M3 2800_1700_M3 3
R_h_M3_8_7 2800_1700_M3 2900_1700_M3 3
R_h_M3_0_8 2000_1800_M3 2100_1800_M3 3
R_h_M3_1_8 2100_1800_M3 2200_1800_M3 3
R_h_M3_2_8 2200_1800_M3 2300_1800_M3 3
R_h_M3_3_8 2300_1800_M3 2400_1800_M3 3
R_h_M3_4_8 2400_1800_M3 2500_1800_M3 3
R_h_M3_5_8 2500_1800_M3 2600_1800_M3 3
R_h_M3_6_8 2600_1800_M3 2700_1800_M3 3
R_h_M3_7_8 2700_1800_M3 2800_1800_M3 3
R_h_M3_8_8 2800_1800_M3 2900_1800_M3 3
R_h_M3_0_9 2000_1900_M3 2100_1900_M3 3
R_h_M3_1_9 2100_1900_M3 2200_1900_M3 3
R_h_M3_2_9 2200_1900_M3 2300_1900_M3 3
R_h_M3_3_9 2300_1900_M3 2400_1900_M3 3
R_h_M3_4_9 2400_1900_M3 2500_1900_M3 3
R_h_M3_5_9 2500_1900_M3 2600_1900_M3 3
R_h_M3_6_9 2600_1900_M3 2700_1900_M3 3
R_h_M3_7_9 2700_1900_M3 2800_1900_M3 3
R_h_M3_8_9 2800_1900_M3 2900_1900_M3 3
* Vertical resistors (R=4 Ohm)
R_v_M3_0_0 2000_1000_M3 2000_1100_M3 4
R_v_M3_1_0 2100_1000_M3 2100_1100_M3 4
R_v_M3_2_0 2200_1000_M3 2200_1100_M3 4
R_v_M3_3_0 2300_1000_M3 2300_1100_M3 4
R_v_M3_4_0 2400_1000_M3 2400_1100_M3 4
R_v_M3_5_0 2500_1000_M3 2500_1100_M3 4
R_v_M3_6_0 2600_1000_M3 2600_1100_M3 4
R_v_M3_7_0 2700_1000_M3 2700_1100_M3 4
R_v_M3_8_0 2800_1000_M3 2800_1100_M3 4
R_v_M3_9_0 2900_1000_M3 2900_1100_M3 4
R_v_M3_0_1 2000_1100_M3 2000_1200_M3 4
R_v_M3_1_1 2100_1100_M3 2100_1200_M3 4
R_v_M3_2_1 2200_1100_M3 2200_1200_M3 4
R_v_M3_3_1 2300_1100_M3 2300_1200_M3 4
R_v_M3_4_1 2400_1100_M3 2400_1200_M3 4
R_v_M3_5_1 2500_1100_M3 2500_1200_M3 4
R_v_M3_6_1 2600_1100_M3 2600_1200_M3 4
R_v_M3_7_1 2700_1100_M3 2700_1200_M3 4
R_v_M3_8_1 2800_1100_M3 2800_1200_M3 4
R_v_M3_9_1 2900_1100_M3 2900_1200_M3 4
R_v_M3_0_2 2000_1200_M3 2000_1300_M3 4
R_v_M3_1_2 2100_1200_M3 2100_1300_M3 4
R_v_M3_2_2 2200_1200_M3 2200_1300_M3 4
R_v_M3_3_2 2300_1200_M3 2300_1300_M3 4
R_v_M3_4_2 2400_1200_M3 2400_1300_M3 4
R_v_M3_5_2 2500_1200_M3 2500_1300_M3 4
R_v_M3_6_2 2600_1200_M3 2600_1300_M3 4
R_v_M3_7_2 2700_1200_M3 2700_1300_M3 4
R_v_M3_8_2 2800_1200_M3 2800_1300_M3 4
R_v_M3_9_2 2900_1200_M3 2900_1300_M3 4
R_v_M3_0_3 2000_1300_M3 2000_1400_M3 4
R_v_M3_1_3 2100_1300_M3 2100_1400_M3 4
R_v_M3_2_3 2200_1300_M3 2200_1400_M3 4
R_v_M3_3_3 2300_1300_M3 2300_1400_M3 4
R_v_M3_4_3 2400_1300_M3 2400_1400_M3 4
R_v_M3_5_3 2500_1300_M3 2500_1400_M3 4
R_v_M3_6_3 2600_1300_M3 2600_1400_M3 4
R_v_M3_7_3 2700_1300_M3 2700_1400_M3 4
R_v_M3_8_3 2800_1300_M3 2800_1400_M3 4
R_v_M3_9_3 2900_1300_M3 2900_1400_M3 4
R_v_M3_0_4 2000_1400_M3 2000_1500_M3 4
R_v_M3_1_4 2100_1400_M3 2100_1500_M3 4
R_v_M3_2_4 2200_1400_M3 2200_1500_M3 4
R_v_M3_3_4 2300_1400_M3 2300_1500_M3 4
R_v_M3_4_4 2400_1400_M3 2400_1500_M3 4
R_v_M3_5_4 2500_1400_M3 2500_1500_M3 4
R_v_M3_6_4 2600_1400_M3 2600_1500_M3 4
R_v_M3_7_4 2700_1400_M3 2700_1500_M3 4
R_v_M3_8_4 2800_1400_M3 2800_1500_M3 4
R_v_M3_9_4 2900_1400_M3 2900_1500_M3 4
R_v_M3_0_5 2000_1500_M3 2000_1600_M3 4
R_v_M3_1_5 2100_1500_M3 2100_1600_M3 4
R_v_M3_2_5 2200_1500_M3 2200_1600_M3 4
R_v_M3_3_5 2300_1500_M3 2300_1600_M3 4
R_v_M3_4_5 2400_1500_M3 2400_1600_M3 4
R_v_M3_5_5 2500_1500_M3 2500_1600_M3 4
R_v_M3_6_5 2600_1500_M3 2600_1600_M3 4
R_v_M3_7_5 2700_1500_M3 2700_1600_M3 4
R_v_M3_8_5 2800_1500_M3 2800_1600_M3 4
R_v_M3_9_5 2900_1500_M3 2900_1600_M3 4
R_v_M3_0_6 2000_1600_M3 2000_1700_M3 4
R_v_M3_1_6 2100_1600_M3 2100_1700_M3 4
R_v_M3_2_6 2200_1600_M3 2200_1700_M3 4
R_v_M3_3_6 2300_1600_M3 2300_1700_M3 4
R_v_M3_4_6 2400_1600_M3 2400_1700_M3 4
R_v_M3_5_6 2500_1600_M3 2500_1700_M3 4
R_v_M3_6_6 2600_1600_M3 2600_1700_M3 4
R_v_M3_7_6 2700_1600_M3 2700_1700_M3 4
R_v_M3_8_6 2800_1600_M3 2800_1700_M3 4
R_v_M3_9_6 2900_1600_M3 2900_1700_M3 4
R_v_M3_0_7 2000_1700_M3 2000_1800_M3 4
R_v_M3_1_7 2100_1700_M3 2100_1800_M3 4
R_v_M3_2_7 2200_1700_M3 2200_1800_M3 4
R_v_M3_3_7 2300_1700_M3 2300_1800_M3 4
R_v_M3_4_7 2400_1700_M3 2400_1800_M3 4
R_v_M3_5_7 2500_1700_M3 2500_1800_M3 4
R_v_M3_6_7 2600_1700_M3 2600_1800_M3 4
R_v_M3_7_7 2700_1700_M3 2700_1800_M3 4
R_v_M3_8_7 2800_1700_M3 2800_1800_M3 4
R_v_M3_9_7 2900_1700_M3 2900_1800_M3 4
R_v_M3_0_8 2000_1800_M3 2000_1900_M3 4
R_v_M3_1_8 2100_1800_M3 2100_1900_M3 4
R_v_M3_2_8 2200_1800_M3 2200_1900_M3 4
R_v_M3_3_8 2300_1800_M3 2300_1900_M3 4
R_v_M3_4_8 2400_1800_M3 2400_1900_M3 4
R_v_M3_5_8 2500_1800_M3 2500_1900_M3 4
R_v_M3_6_8 2600_1800_M3 2600_1900_M3 4
R_v_M3_7_8 2700_1800_M3 2700_1900_M3 4
R_v_M3_8_8 2800_1800_M3 2800_1900_M3 4
R_v_M3_9_8 2900_1800_M3 2900_1900_M3 4
* Ground capacitors (C=2.0 fF)
C_g_M3_0_0 2000_1000_M3 0 2e-15
C_g_M3_1_0 2100_1000_M3 0 2e-15
C_g_M3_2_0 2200_1000_M3 0 2e-15
C_g_M3_3_0 2300_1000_M3 0 2e-15
C_g_M3_4_0 2400_1000_M3 0 2e-15
C_g_M3_5_0 2500_1000_M3 0 2e-15
C_g_M3_6_0 2600_1000_M3 0 2e-15
C_g_M3_7_0 2700_1000_M3 0 2e-15
C_g_M3_8_0 2800_1000_M3 0 2e-15
C_g_M3_9_0 2900_1000_M3 0 2e-15
C_g_M3_0_1 2000_1100_M3 0 2e-15
C_g_M3_1_1 2100_1100_M3 0 2e-15
C_g_M3_2_1 2200_1100_M3 0 2e-15
C_g_M3_3_1 2300_1100_M3 0 2e-15
C_g_M3_4_1 2400_1100_M3 0 2e-15
C_g_M3_5_1 2500_1100_M3 0 2e-15
C_g_M3_6_1 2600_1100_M3 0 2e-15
C_g_M3_7_1 2700_1100_M3 0 2e-15
C_g_M3_8_1 2800_1100_M3 0 2e-15
C_g_M3_9_1 2900_1100_M3 0 2e-15
C_g_M3_0_2 2000_1200_M3 0 2e-15
C_g_M3_1_2 2100_1200_M3 0 2e-15
C_g_M3_2_2 2200_1200_M3 0 2e-15
C_g_M3_3_2 2300_1200_M3 0 2e-15
C_g_M3_4_2 2400_1200_M3 0 2e-15
C_g_M3_5_2 2500_1200_M3 0 2e-15
C_g_M3_6_2 2600_1200_M3 0 2e-15
C_g_M3_7_2 2700_1200_M3 0 2e-15
C_g_M3_8_2 2800_1200_M3 0 2e-15
C_g_M3_9_2 2900_1200_M3 0 2e-15
C_g_M3_0_3 2000_1300_M3 0 2e-15
C_g_M3_1_3 2100_1300_M3 0 2e-15
C_g_M3_2_3 2200_1300_M3 0 2e-15
C_g_M3_3_3 2300_1300_M3 0 2e-15
C_g_M3_4_3 2400_1300_M3 0 2e-15
C_g_M3_5_3 2500_1300_M3 0 2e-15
C_g_M3_6_3 2600_1300_M3 0 2e-15
C_g_M3_7_3 2700_1300_M3 0 2e-15
C_g_M3_8_3 2800_1300_M3 0 2e-15
C_g_M3_9_3 2900_1300_M3 0 2e-15
C_g_M3_0_4 2000_1400_M3 0 2e-15
C_g_M3_1_4 2100_1400_M3 0 2e-15
C_g_M3_2_4 2200_1400_M3 0 2e-15
C_g_M3_3_4 2300_1400_M3 0 2e-15
C_g_M3_4_4 2400_1400_M3 0 2e-15
C_g_M3_5_4 2500_1400_M3 0 2e-15
C_g_M3_6_4 2600_1400_M3 0 2e-15
C_g_M3_7_4 2700_1400_M3 0 2e-15
C_g_M3_8_4 2800_1400_M3 0 2e-15
C_g_M3_9_4 2900_1400_M3 0 2e-15
C_g_M3_0_5 2000_1500_M3 0 2e-15
C_g_M3_1_5 2100_1500_M3 0 2e-15
C_g_M3_2_5 2200_1500_M3 0 2e-15
C_g_M3_3_5 2300_1500_M3 0 2e-15
C_g_M3_4_5 2400_1500_M3 0 2e-15
C_g_M3_5_5 2500_1500_M3 0 2e-15
C_g_M3_6_5 2600_1500_M3 0 2e-15
C_g_M3_7_5 2700_1500_M3 0 2e-15
C_g_M3_8_5 2800_1500_M3 0 2e-15
C_g_M3_9_5 2900_1500_M3 0 2e-15
C_g_M3_0_6 2000_1600_M3 0 2e-15
C_g_M3_1_6 2100_1600_M3 0 2e-15
C_g_M3_2_6 2200_1600_M3 0 2e-15
C_g_M3_3_6 2300_1600_M3 0 2e-15
C_g_M3_4_6 2400_1600_M3 0 2e-15
C_g_M3_5_6 2500_1600_M3 0 2e-15
C_g_M3_6_6 2600_1600_M3 0 2e-15
C_g_M3_7_6 2700_1600_M3 0 2e-15
C_g_M3_8_6 2800_1600_M3 0 2e-15
C_g_M3_9_6 2900_1600_M3 0 2e-15
C_g_M3_0_7 2000_1700_M3 0 2e-15
C_g_M3_1_7 2100_1700_M3 0 2e-15
C_g_M3_2_7 2200_1700_M3 0 2e-15
C_g_M3_3_7 2300_1700_M3 0 2e-15
C_g_M3_4_7 2400_1700_M3 0 2e-15
C_g_M3_5_7 2500_1700_M3 0 2e-15
C_g_M3_6_7 2600_1700_M3 0 2e-15
C_g_M3_7_7 2700_1700_M3 0 2e-15
C_g_M3_8_7 2800_1700_M3 0 2e-15
C_g_M3_9_7 2900_1700_M3 0 2e-15
C_g_M3_0_8 2000_1800_M3 0 2e-15
C_g_M3_1_8 2100_1800_M3 0 2e-15
C_g_M3_2_8 2200_1800_M3 0 2e-15
C_g_M3_3_8 2300_1800_M3 0 2e-15
C_g_M3_4_8 2400_1800_M3 0 2e-15
C_g_M3_5_8 2500_1800_M3 0 2e-15
C_g_M3_6_8 2600_1800_M3 0 2e-15
C_g_M3_7_8 2700_1800_M3 0 2e-15
C_g_M3_8_8 2800_1800_M3 0 2e-15
C_g_M3_9_8 2900_1800_M3 0 2e-15
C_g_M3_0_9 2000_1900_M3 0 2e-15
C_g_M3_1_9 2100_1900_M3 0 2e-15
C_g_M3_2_9 2200_1900_M3 0 2e-15
C_g_M3_3_9 2300_1900_M3 0 2e-15
C_g_M3_4_9 2400_1900_M3 0 2e-15
C_g_M3_5_9 2500_1900_M3 0 2e-15
C_g_M3_6_9 2600_1900_M3 0 2e-15
C_g_M3_7_9 2700_1900_M3 0 2e-15
C_g_M3_8_9 2800_1900_M3 0 2e-15
C_g_M3_9_9 2900_1900_M3 0 2e-15
* Coupling capacitors (C=1.0 fF)
C_coup_M3_0_0 2000_1000_M3 2100_1000_M3 1e-15
C_coup_M3_2_0 2200_1000_M3 2300_1000_M3 1e-15
C_coup_M3_4_0 2400_1000_M3 2500_1000_M3 1e-15
C_coup_M3_6_0 2600_1000_M3 2700_1000_M3 1e-15
C_coup_M3_8_0 2800_1000_M3 2900_1000_M3 1e-15
C_coup_M3_0_1 2000_1100_M3 2100_1100_M3 1e-15
C_coup_M3_2_1 2200_1100_M3 2300_1100_M3 1e-15
C_coup_M3_4_1 2400_1100_M3 2500_1100_M3 1e-15
C_coup_M3_6_1 2600_1100_M3 2700_1100_M3 1e-15
C_coup_M3_8_1 2800_1100_M3 2900_1100_M3 1e-15
C_coup_M3_0_2 2000_1200_M3 2100_1200_M3 1e-15
C_coup_M3_2_2 2200_1200_M3 2300_1200_M3 1e-15
C_coup_M3_4_2 2400_1200_M3 2500_1200_M3 1e-15
C_coup_M3_6_2 2600_1200_M3 2700_1200_M3 1e-15
C_coup_M3_8_2 2800_1200_M3 2900_1200_M3 1e-15
C_coup_M3_0_3 2000_1300_M3 2100_1300_M3 1e-15
C_coup_M3_2_3 2200_1300_M3 2300_1300_M3 1e-15
C_coup_M3_4_3 2400_1300_M3 2500_1300_M3 1e-15
C_coup_M3_6_3 2600_1300_M3 2700_1300_M3 1e-15
C_coup_M3_8_3 2800_1300_M3 2900_1300_M3 1e-15
C_coup_M3_0_4 2000_1400_M3 2100_1400_M3 1e-15
C_coup_M3_2_4 2200_1400_M3 2300_1400_M3 1e-15
C_coup_M3_4_4 2400_1400_M3 2500_1400_M3 1e-15
C_coup_M3_6_4 2600_1400_M3 2700_1400_M3 1e-15
C_coup_M3_8_4 2800_1400_M3 2900_1400_M3 1e-15
C_coup_M3_0_5 2000_1500_M3 2100_1500_M3 1e-15
C_coup_M3_2_5 2200_1500_M3 2300_1500_M3 1e-15
C_coup_M3_4_5 2400_1500_M3 2500_1500_M3 1e-15
C_coup_M3_6_5 2600_1500_M3 2700_1500_M3 1e-15
C_coup_M3_8_5 2800_1500_M3 2900_1500_M3 1e-15
C_coup_M3_0_6 2000_1600_M3 2100_1600_M3 1e-15
C_coup_M3_2_6 2200_1600_M3 2300_1600_M3 1e-15
C_coup_M3_4_6 2400_1600_M3 2500_1600_M3 1e-15
C_coup_M3_6_6 2600_1600_M3 2700_1600_M3 1e-15
C_coup_M3_8_6 2800_1600_M3 2900_1600_M3 1e-15
C_coup_M3_0_7 2000_1700_M3 2100_1700_M3 1e-15
C_coup_M3_2_7 2200_1700_M3 2300_1700_M3 1e-15
C_coup_M3_4_7 2400_1700_M3 2500_1700_M3 1e-15
C_coup_M3_6_7 2600_1700_M3 2700_1700_M3 1e-15
C_coup_M3_8_7 2800_1700_M3 2900_1700_M3 1e-15
C_coup_M3_0_8 2000_1800_M3 2100_1800_M3 1e-15
C_coup_M3_2_8 2200_1800_M3 2300_1800_M3 1e-15
C_coup_M3_4_8 2400_1800_M3 2500_1800_M3 1e-15
C_coup_M3_6_8 2600_1800_M3 2700_1800_M3 1e-15
C_coup_M3_8_8 2800_1800_M3 2900_1800_M3 1e-15
C_coup_M3_0_9 2000_1900_M3 2100_1900_M3 1e-15
C_coup_M3_2_9 2200_1900_M3 2300_1900_M3 1e-15
C_coup_M3_4_9 2400_1900_M3 2500_1900_M3 1e-15
C_coup_M3_6_9 2600_1900_M3 2700_1900_M3 1e-15
C_coup_M3_8_9 2800_1900_M3 2900_1900_M3 1e-15

* ========== Via connections ==========
* Vias M1 to M2 (R=0.5 Ohm)
R_via_M1_M2_0_0 2000_1000_M1 2000_1000_M2 0.5
R_via_M1_M2_2_0 2200_1000_M1 2200_1000_M2 0.5
R_via_M1_M2_4_0 2400_1000_M1 2400_1000_M2 0.5
R_via_M1_M2_6_0 2600_1000_M1 2600_1000_M2 0.5
R_via_M1_M2_8_0 2800_1000_M1 2800_1000_M2 0.5
R_via_M1_M2_0_2 2000_1200_M1 2000_1200_M2 0.5
R_via_M1_M2_2_2 2200_1200_M1 2200_1200_M2 0.5
R_via_M1_M2_4_2 2400_1200_M1 2400_1200_M2 0.5
R_via_M1_M2_6_2 2600_1200_M1 2600_1200_M2 0.5
R_via_M1_M2_8_2 2800_1200_M1 2800_1200_M2 0.5
R_via_M1_M2_0_4 2000_1400_M1 2000_1400_M2 0.5
R_via_M1_M2_2_4 2200_1400_M1 2200_1400_M2 0.5
R_via_M1_M2_4_4 2400_1400_M1 2400_1400_M2 0.5
R_via_M1_M2_6_4 2600_1400_M1 2600_1400_M2 0.5
R_via_M1_M2_8_4 2800_1400_M1 2800_1400_M2 0.5
R_via_M1_M2_0_6 2000_1600_M1 2000_1600_M2 0.5
R_via_M1_M2_2_6 2200_1600_M1 2200_1600_M2 0.5
R_via_M1_M2_4_6 2400_1600_M1 2400_1600_M2 0.5
R_via_M1_M2_6_6 2600_1600_M1 2600_1600_M2 0.5
R_via_M1_M2_8_6 2800_1600_M1 2800_1600_M2 0.5
R_via_M1_M2_0_8 2000_1800_M1 2000_1800_M2 0.5
R_via_M1_M2_2_8 2200_1800_M1 2200_1800_M2 0.5
R_via_M1_M2_4_8 2400_1800_M1 2400_1800_M2 0.5
R_via_M1_M2_6_8 2600_1800_M1 2600_1800_M2 0.5
R_via_M1_M2_8_8 2800_1800_M1 2800_1800_M2 0.5
* Vias M2 to M3 (R=0.3 Ohm)
R_via_M2_M3_0_0 2000_1000_M2 2000_1000_M3 0.3
R_via_M2_M3_2_0 2200_1000_M2 2200_1000_M3 0.3
R_via_M2_M3_4_0 2400_1000_M2 2400_1000_M3 0.3
R_via_M2_M3_6_0 2600_1000_M2 2600_1000_M3 0.3
R_via_M2_M3_8_0 2800_1000_M2 2800_1000_M3 0.3
R_via_M2_M3_0_2 2000_1200_M2 2000_1200_M3 0.3
R_via_M2_M3_2_2 2200_1200_M2 2200_1200_M3 0.3
R_via_M2_M3_4_2 2400_1200_M2 2400_1200_M3 0.3
R_via_M2_M3_6_2 2600_1200_M2 2600_1200_M3 0.3
R_via_M2_M3_8_2 2800_1200_M2 2800_1200_M3 0.3
R_via_M2_M3_0_4 2000_1400_M2 2000_1400_M3 0.3
R_via_M2_M3_2_4 2200_1400_M2 2200_1400_M3 0.3
R_via_M2_M3_4_4 2400_1400_M2 2400_1400_M3 0.3
R_via_M2_M3_6_4 2600_1400_M2 2600_1400_M3 0.3
R_via_M2_M3_8_4 2800_1400_M2 2800_1400_M3 0.3
R_via_M2_M3_0_6 2000_1600_M2 2000_1600_M3 0.3
R_via_M2_M3_2_6 2200_1600_M2 2200_1600_M3 0.3
R_via_M2_M3_4_6 2400_1600_M2 2400_1600_M3 0.3
R_via_M2_M3_6_6 2600_1600_M2 2600_1600_M3 0.3
R_via_M2_M3_8_6 2800_1600_M2 2800_1600_M3 0.3
R_via_M2_M3_0_8 2000_1800_M2 2000_1800_M3 0.3
R_via_M2_M3_2_8 2200_1800_M2 2200_1800_M3 0.3
R_via_M2_M3_4_8 2400_1800_M2 2400_1800_M3 0.3
R_via_M2_M3_6_8 2600_1800_M2 2600_1800_M3 0.3
R_via_M2_M3_8_8 2800_1800_M2 2800_1800_M3 0.3

* ========== Decoupling capacitors ==========
C_decap_1_1 2100_1100_M1 0 2e-13
C_decap_4_1 2400_1100_M1 0 5e-14
C_decap_7_1 2700_1100_M1 0 2e-13
C_decap_1_4 2100_1400_M1 0 5e-14
C_decap_4_4 2400_1400_M1 0 2e-13
C_decap_7_4 2700_1400_M1 0 5e-14
C_decap_1_7 2100_1700_M1 0 2e-13
C_decap_4_7 2400_1700_M1 0 5e-14
C_decap_7_7 2700_1700_M1 0 2e-13
* (9 decaps placed)

* ========== Boundary connections ==========
* Top boundary to tile_2_2
R_bnd_t_M1_0 *2000_1900_M1 *2000_2000_M1 10
R_bnd_t_M2_0 *2000_1900_M2 *2000_2000_M2 6
R_bnd_t_M3_0 *2000_1900_M3 *2000_2000_M3 4
R_bnd_t_M1_1 *2100_1900_M1 *2100_2000_M1 10
R_bnd_t_M2_1 *2100_1900_M2 *2100_2000_M2 6
R_bnd_t_M3_1 *2100_1900_M3 *2100_2000_M3 4
R_bnd_t_M1_2 *2200_1900_M1 *2200_2000_M1 10
R_bnd_t_M2_2 *2200_1900_M2 *2200_2000_M2 6
R_bnd_t_M3_2 *2200_1900_M3 *2200_2000_M3 4
R_bnd_t_M1_3 *2300_1900_M1 *2300_2000_M1 10
R_bnd_t_M2_3 *2300_1900_M2 *2300_2000_M2 6
R_bnd_t_M3_3 *2300_1900_M3 *2300_2000_M3 4
R_bnd_t_M1_4 *2400_1900_M1 *2400_2000_M1 10
R_bnd_t_M2_4 *2400_1900_M2 *2400_2000_M2 6
R_bnd_t_M3_4 *2400_1900_M3 *2400_2000_M3 4
R_bnd_t_M1_5 *2500_1900_M1 *2500_2000_M1 10
R_bnd_t_M2_5 *2500_1900_M2 *2500_2000_M2 6
R_bnd_t_M3_5 *2500_1900_M3 *2500_2000_M3 4
R_bnd_t_M1_6 *2600_1900_M1 *2600_2000_M1 10
R_bnd_t_M2_6 *2600_1900_M2 *2600_2000_M2 6
R_bnd_t_M3_6 *2600_1900_M3 *2600_2000_M3 4
R_bnd_t_M1_7 *2700_1900_M1 *2700_2000_M1 10
R_bnd_t_M2_7 *2700_1900_M2 *2700_2000_M2 6
R_bnd_t_M3_7 *2700_1900_M3 *2700_2000_M3 4
R_bnd_t_M1_8 *2800_1900_M1 *2800_2000_M1 10
R_bnd_t_M2_8 *2800_1900_M2 *2800_2000_M2 6
R_bnd_t_M3_8 *2800_1900_M3 *2800_2000_M3 4
R_bnd_t_M1_9 *2900_1900_M1 *2900_2000_M1 10
R_bnd_t_M2_9 *2900_1900_M2 *2900_2000_M2 6
R_bnd_t_M3_9 *2900_1900_M3 *2900_2000_M3 4

* Tile 2_1 summary: 620 R, 459 C
