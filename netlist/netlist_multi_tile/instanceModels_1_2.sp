* Instance models for tile 1_2
* Current sources with static and dynamic currents
* Some nodes have multiple current sources (overlapping)

I_1_2_6_2 1600_2200_M1 0 1.5642e-03
I_1_2_7_5 1700_2500_M1 0 5.9239e-04 static_value=2.6910e-04
I_1_2_6_5 1600_2500_M1 0 0 pulse(1.0428e-05, 1.6495e-03, 1.6026e-09, 3.4725e-10, 4.3281e-10, 4.7593e-09, 8.6169e-09)
I_1_2_1_4 1100_2400_M1 0 0 pwl(0.0000e+00 6.0829e-04 2.1777e-09 1.3099e-03 3.9693e-09 7.7569e-04 5.6483e-09 8.3267e-04) pwl_period=8.4951e-09
I_1_2_4_4 1400_2400_M1 0 2.3421e-04 pulse(0, 1.0100e-03, 0, 0.2n, 0.2n, 5.7178e-09, 1.3494e-08)
I_1_2_5_0 1500_2000_M1 0 3.1821e-04 pwl(0 0 2n 9.0947e-04 5n 1.8150e-03 8n 4.1813e-04) pwl_period=10n
I_1_2_6_7 1600_2700_M1 0 7.1967e-04
I_1_2_9_6 1900_2600_M1 0 4.3809e-04 static_value=5.6144e-04
I_1_2_7_6 1700_2600_M1 0 0 pulse(3.8011e-04, 2.3110e-03, 3.5429e-10, 4.0914e-10, 2.9765e-10, 4.2633e-09, 1.3319e-08)
I_1_2_3_9 1300_2900_M1 0 0 pwl(0.0000e+00 1.7028e-03 2.7641e-09 1.6075e-03 5.7372e-09 8.0802e-04 8.6791e-09 7.9035e-04 1.0559e-08 1.1723e-03 1.2821e-08 1.9908e-03 1.5004e-08 8.7986e-04) pwl_period=1.7614e-08
I_1_2_2_8 1200_2800_M1 0 2.1128e-04 pulse(0, 8.6874e-04, 0, 0.2n, 0.2n, 3.8612e-09, 1.6447e-08)
I_1_2_2_7 1200_2700_M1 0 3.9321e-04 pwl(0 0 2n 5.4515e-04 5n 1.5941e-03 8n 4.9224e-04) pwl_period=10n
I_1_2_1_4_2 1100_2400_M1 0 1.3705e-03
I_1_2_7_5_2 1700_2500_M1 0 9.6796e-04 static_value=6.4335e-04
I_1_2_3_6 1300_2600_M1 0 0 pulse(2.0511e-05, 2.8181e-03, 1.1433e-09, 1.7530e-10, 3.4200e-10, 3.5041e-09, 1.4704e-08)
I_1_2_6_5_2 1600_2500_M1 0 0 pwl(0.0000e+00 2.5875e-04 2.7983e-09 8.5859e-04 5.2269e-09 1.2614e-03 6.5720e-09 6.1936e-04 8.4475e-09 1.0986e-03 1.0493e-08 3.9687e-04 1.2239e-08 7.0723e-04) pwl_period=1.5395e-08
I_1_2_8_5 1800_2500_M1 0 3.7937e-04 pulse(0, 1.2892e-03, 0, 0.2n, 0.2n, 4.9419e-09, 1.0659e-08)
I_1_2_0_5 1000_2500_M1 0 1.2835e-04 pwl(0 0 2n 8.3919e-04 5n 1.2841e-03 8n 6.6187e-04) pwl_period=10n
I_1_2_7_6_2 1700_2600_M1 0 1.4848e-03
I_1_2_8_6 1800_2600_M1 0 9.3444e-04 static_value=7.2397e-04
I_1_2_2_7_2 1200_2700_M1 0 0 pulse(1.6668e-04, 2.1655e-03, 2.8286e-10, 2.3993e-10, 4.8708e-10, 4.0954e-09, 1.0744e-08)
I_1_2_3_9_2 1300_2900_M1 0 0 pwl(0.0000e+00 1.7721e-03 1.1694e-09 1.3973e-03 3.4564e-09 8.2119e-04 4.7120e-09 1.7571e-03 7.6062e-09 2.4929e-03 1.0431e-08 2.3363e-04 1.2772e-08 1.2712e-03 1.3808e-08 7.7217e-04) pwl_period=1.8053e-08
I_1_2_4_4_2 1400_2400_M1 0 4.2985e-04 pulse(0, 6.9201e-04, 0, 0.2n, 0.2n, 5.9999e-09, 1.1549e-08)
I_1_2_5_5 1500_2500_M1 0 1.8874e-04 pwl(0 0 2n 8.9406e-04 5n 1.5077e-03 8n 5.6989e-04) pwl_period=10n
I_1_2_0_5_2 1000_2500_M1 0 1.6080e-03

* Tile 1_2 summary:
*   Total current sources: 25
*   With static current: 17
*   With waveforms: 16
*   Overlapping nodes: 8
