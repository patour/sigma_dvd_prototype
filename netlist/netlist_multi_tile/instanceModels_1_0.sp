* Instance models for tile 1_0
* Current sources with static and dynamic currents
* Some nodes have multiple current sources (overlapping)

I_1_0_9_2 1900_200_M1 0 1.9535e-03
I_1_0_6_2 1600_200_M1 0 9.4846e-04 static_value=7.0922e-04
I_1_0_9_2_2 1900_200_M1 0 0 pulse(8.3156e-05, 1.9713e-03, 4.2749e-10, 2.6042e-10, 1.2345e-10, 3.1369e-09, 1.4897e-08)
I_1_0_6_5 1600_500_M1 0 0 pwl(0.0000e+00 2.3163e-03 2.5703e-09 7.1312e-04 4.9634e-09 1.8263e-03 7.5302e-09 1.6547e-03 9.5035e-09 4.7474e-04 1.0939e-08 1.4621e-04) pwl_period=1.4471e-08
I_1_0_7_3 1700_300_M1 0 2.9408e-04 pulse(0, 5.5014e-04, 0, 0.2n, 0.2n, 4.4304e-09, 1.9194e-08)
I_1_0_2_9 1200_900_M1 0 2.5934e-04 pwl(0 0 2n 5.2844e-04 5n 1.5078e-03 8n 7.2567e-04) pwl_period=10n
I_1_0_3_5 1300_500_M1 0 6.0278e-04
I_1_0_4_2 1400_200_M1 0 3.4757e-04 static_value=7.1709e-04
I_1_0_0_9 1000_900_M1 0 0 pulse(2.0189e-04, 2.8832e-03, 1.1394e-09, 3.3157e-10, 1.1590e-10, 2.2460e-09, 1.2602e-08)
I_1_0_6_9 1600_900_M1 0 0 pwl(0.0000e+00 1.3070e-03 2.8694e-09 5.1065e-04 5.3018e-09 5.9671e-04 7.0934e-09 1.6792e-03 8.6934e-09 7.9044e-04 1.1197e-08 1.8136e-04 1.3114e-08 2.4961e-03 1.6106e-08 1.8315e-04) pwl_period=1.8797e-08
I_1_0_6_0 1600_0_M1 0 4.7998e-04 pulse(0, 1.3809e-03, 0, 0.2n, 0.2n, 5.6378e-09, 1.3695e-08)
I_1_0_0_4 1000_400_M1 0 1.4732e-04 pwl(0 0 2n 9.1687e-04 5n 1.7035e-03 8n 6.0584e-04) pwl_period=10n
I_1_0_3_1 1300_100_M1 0 1.9808e-03
I_1_0_8_5 1800_500_M1 0 7.5778e-04 static_value=2.0469e-04
I_1_0_9_2_3 1900_200_M1 0 0 pulse(4.0855e-04, 1.5988e-03, 1.3268e-09, 4.7557e-10, 1.5372e-10, 2.3463e-09, 8.7493e-09)
I_1_0_3_0 1300_0_M1 0 0 pwl(0.0000e+00 3.8862e-04 1.5635e-09 5.2657e-04 3.2493e-09 1.7187e-03 5.9551e-09 1.2635e-03 7.4573e-09 2.2704e-03 8.5589e-09 1.5857e-03 1.1218e-08 1.1022e-04 1.2885e-08 3.2705e-04) pwl_period=1.7006e-08
I_1_0_3_5_2 1300_500_M1 0 3.3255e-04 pulse(0, 1.2057e-03, 0, 0.2n, 0.2n, 4.6827e-09, 1.1119e-08)
I_1_0_1_6 1100_600_M1 0 3.8352e-04 pwl(0 0 2n 8.4551e-04 5n 1.1491e-03 8n 3.1801e-04) pwl_period=10n
I_1_0_2_7 1200_700_M1 0 1.0538e-03
I_1_0_1_6_2 1100_600_M1 0 6.8677e-04 static_value=4.5787e-04
I_1_0_0_8 1000_800_M1 0 0 pulse(2.0914e-05, 1.7293e-03, 1.8662e-09, 4.8888e-10, 1.1596e-10, 3.0734e-09, 1.2774e-08)
I_1_0_4_2_2 1400_200_M1 0 0 pwl(0.0000e+00 8.8420e-04 2.1198e-09 2.1868e-03 5.0674e-09 1.8737e-03 7.9190e-09 5.9184e-04) pwl_period=1.1044e-08
I_1_0_3_5_3 1300_500_M1 0 2.5312e-04 pulse(0, 9.1229e-04, 0, 0.2n, 0.2n, 3.5381e-09, 1.9245e-08)
I_1_0_0_8_2 1000_800_M1 0 3.3472e-04 pwl(0 0 2n 7.0586e-04 5n 1.6699e-03 8n 6.6753e-04) pwl_period=10n
I_1_0_3_5_4 1300_500_M1 0 8.7225e-04

* Tile 1_0 summary:
*   Total current sources: 25
*   With static current: 17
*   With waveforms: 16
*   Overlapping nodes: 8
