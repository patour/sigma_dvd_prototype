* Instance models for tile 2_2
* Current sources with static and dynamic currents
* Some nodes have multiple current sources (overlapping)

I_2_2_0_4 2000_2400_M1 0 9.2759e-04
I_2_2_0_5 2000_2500_M1 0 8.3418e-04 static_value=3.6367e-04
I_2_2_7_9 2700_2900_M1 0 0 pulse(4.5265e-04, 1.2947e-03, 8.7495e-10, 4.7857e-10, 1.8882e-10, 3.3534e-09, 1.0447e-08)
I_2_2_4_8 2400_2800_M1 0 0 pwl(0.0000e+00 1.0372e-03 1.7929e-09 9.3490e-04 3.5652e-09 2.0401e-04 5.0143e-09 7.9671e-04) pwl_period=7.9272e-09
I_2_2_9_8 2900_2800_M1 0 3.0059e-04 pulse(0, 6.4605e-04, 0, 0.2n, 0.2n, 3.1149e-09, 1.9174e-08)
I_2_2_2_0 2200_2000_M1 0 2.4174e-04 pwl(0 0 2n 9.1556e-04 5n 1.7588e-03 8n 5.3456e-04) pwl_period=10n
I_2_2_8_8 2800_2800_M1 0 1.4230e-03
I_2_2_7_6 2700_2600_M1 0 9.3410e-04 static_value=2.1140e-04
I_2_2_6_7 2600_2700_M1 0 0 pulse(1.0783e-04, 1.2990e-03, 1.8805e-09, 3.4355e-10, 2.6930e-10, 4.3285e-09, 9.6635e-09)
I_2_2_9_8_2 2900_2800_M1 0 0 pwl(0.0000e+00 1.1937e-04 1.8397e-09 1.9847e-03 3.7539e-09 2.7714e-04 6.5642e-09 1.4918e-03) pwl_period=9.1124e-09
I_2_2_7_6_2 2700_2600_M1 0 2.7258e-04 pulse(0, 6.4358e-04, 0, 0.2n, 0.2n, 4.2877e-09, 1.6148e-08)
I_2_2_1_6 2100_2600_M1 0 1.7217e-04 pwl(0 0 2n 7.0828e-04 5n 1.6644e-03 8n 3.4281e-04) pwl_period=10n
I_2_2_4_3 2400_2300_M1 0 1.9620e-03
I_2_2_7_6_3 2700_2600_M1 0 3.4738e-04 static_value=5.1564e-04
I_2_2_8_4 2800_2400_M1 0 0 pulse(2.5366e-04, 2.9767e-03, 1.1083e-09, 2.5618e-10, 2.8805e-10, 3.9070e-09, 1.4867e-08)
I_2_2_2_1 2200_2100_M1 0 0 pwl(0.0000e+00 1.8683e-03 1.7142e-09 1.6890e-04 3.1964e-09 1.6428e-03 4.4038e-09 1.4548e-03 6.9171e-09 3.3352e-04 8.6217e-09 8.4637e-04) pwl_period=1.2738e-08
I_2_2_8_8_2 2800_2800_M1 0 4.0540e-04 pulse(0, 1.4808e-03, 0, 0.2n, 0.2n, 4.4356e-09, 1.1823e-08)
I_2_2_1_9 2100_2900_M1 0 1.4046e-04 pwl(0 0 2n 8.5802e-04 5n 1.9436e-03 8n 3.1849e-04) pwl_period=10n
I_2_2_9_8_3 2900_2800_M1 0 8.0239e-04
I_2_2_9_2 2900_2200_M1 0 8.5378e-04 static_value=7.3147e-04
I_2_2_2_3 2200_2300_M1 0 0 pulse(1.5780e-04, 1.6202e-03, 7.9645e-10, 4.2616e-10, 2.8936e-10, 2.1099e-09, 1.2528e-08)
I_2_2_2_3_2 2200_2300_M1 0 0 pwl(0.0000e+00 8.9244e-04 2.5617e-09 2.1645e-03 4.2255e-09 3.1119e-04 5.9616e-09 2.2237e-03 8.4482e-09 2.2366e-03 1.0221e-08 2.4343e-03) pwl_period=1.3711e-08
I_2_2_1_6_2 2100_2600_M1 0 4.7729e-04 pulse(0, 1.0193e-03, 0, 0.2n, 0.2n, 5.4034e-09, 1.7271e-08)
I_2_2_5_6 2500_2600_M1 0 1.2368e-04 pwl(0 0 2n 8.0123e-04 5n 1.8223e-03 8n 5.7274e-04) pwl_period=10n
I_2_2_1_9_2 2100_2900_M1 0 9.8182e-04

* Tile 2_2 summary:
*   Total current sources: 25
*   With static current: 17
*   With waveforms: 16
*   Overlapping nodes: 8
