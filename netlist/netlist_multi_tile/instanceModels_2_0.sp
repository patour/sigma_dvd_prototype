* Instance models for tile 2_0
* Current sources with static and dynamic currents
* Some nodes have multiple current sources (overlapping)

I_2_0_0_4 2000_400_M1 0 5.0254e-04
I_2_0_4_2 2400_200_M1 0 9.4790e-04 static_value=5.2307e-04
I_2_0_2_5 2200_500_M1 0 0 pulse(3.5971e-04, 2.4839e-03, 1.3413e-09, 2.4569e-10, 1.2799e-10, 3.9927e-09, 1.0311e-08)
I_2_0_6_0 2600_0_M1 0 0 pwl(0.0000e+00 1.6585e-03 1.2493e-09 2.2501e-03 3.2635e-09 1.6672e-03 4.9159e-09 1.7430e-03 7.0247e-09 4.7960e-04 9.3545e-09 9.4786e-04) pwl_period=1.3025e-08
I_2_0_1_3 2100_300_M1 0 3.7073e-04 pulse(0, 9.0608e-04, 0, 0.2n, 0.2n, 5.5012e-09, 1.3039e-08)
I_2_0_3_9 2300_900_M1 0 1.6305e-04 pwl(0 0 2n 8.9288e-04 5n 1.6067e-03 8n 4.6112e-04) pwl_period=10n
I_2_0_0_4_2 2000_400_M1 0 1.1627e-03
I_2_0_2_4 2200_400_M1 0 7.7294e-04 static_value=5.0670e-04
I_2_0_6_0_2 2600_0_M1 0 0 pulse(3.9687e-04, 2.9197e-03, 1.4719e-09, 3.6354e-10, 2.1351e-10, 3.9916e-09, 1.2335e-08)
I_2_0_8_4 2800_400_M1 0 0 pwl(0.0000e+00 2.0461e-03 2.5023e-09 1.6820e-03 3.9516e-09 4.9782e-04 5.0004e-09 6.1211e-04) pwl_period=8.8004e-09
I_2_0_4_4 2400_400_M1 0 2.2185e-04 pulse(0, 9.1444e-04, 0, 0.2n, 0.2n, 4.8893e-09, 1.1944e-08)
I_2_0_2_8 2200_800_M1 0 3.0891e-04 pwl(0 0 2n 7.4719e-04 5n 1.2440e-03 8n 6.2803e-04) pwl_period=10n
I_2_0_5_8 2500_800_M1 0 5.0832e-04
I_2_0_0_3 2000_300_M1 0 8.2568e-04 static_value=6.6203e-04
I_2_0_5_1 2500_100_M1 0 0 pulse(5.3294e-05, 1.8503e-03, 3.5177e-10, 4.8319e-10, 3.0718e-10, 2.1507e-09, 9.7444e-09)
I_2_0_2_9 2200_900_M1 0 0 pwl(0.0000e+00 1.1412e-03 2.6028e-09 1.6689e-03 5.5786e-09 1.4886e-03 8.4787e-09 2.2286e-03) pwl_period=1.2423e-08
I_2_0_8_4_2 2800_400_M1 0 3.5143e-04 pulse(0, 1.3306e-03, 0, 0.2n, 0.2n, 4.6436e-09, 1.8972e-08)
I_2_0_2_4_2 2200_400_M1 0 3.2310e-04 pwl(0 0 2n 7.3734e-04 5n 1.2592e-03 8n 4.2362e-04) pwl_period=10n
I_2_0_8_9 2800_900_M1 0 1.4565e-03
I_2_0_2_9_2 2200_900_M1 0 8.3607e-04 static_value=5.1278e-04
I_2_0_8_9_2 2800_900_M1 0 0 pulse(3.1337e-04, 1.5492e-03, 1.5497e-10, 2.1429e-10, 2.0869e-10, 2.9591e-09, 1.1781e-08)
I_2_0_6_0_3 2600_0_M1 0 0 pwl(0.0000e+00 3.7708e-04 1.7661e-09 3.8201e-04 3.1940e-09 1.0372e-03 4.8557e-09 1.1648e-03 5.9803e-09 2.0822e-03) pwl_period=9.5290e-09
I_2_0_5_8_2 2500_800_M1 0 4.8382e-04 pulse(0, 5.1953e-04, 0, 0.2n, 0.2n, 5.6420e-09, 1.5757e-08)
I_2_0_4_8 2400_800_M1 0 2.4309e-04 pwl(0 0 2n 9.7137e-04 5n 1.2986e-03 8n 4.9499e-04) pwl_period=10n
I_2_0_2_0 2200_0_M1 0 1.8375e-03

* Tile 2_0 summary:
*   Total current sources: 25
*   With static current: 17
*   With waveforms: 16
*   Overlapping nodes: 8
