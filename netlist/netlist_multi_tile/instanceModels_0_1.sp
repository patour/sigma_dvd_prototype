* Instance models for tile 0_1
* Current sources with static and dynamic currents
* Some nodes have multiple current sources (overlapping)

I_0_1_9_5 900_1500_M1 0 1.4752e-03
I_0_1_5_5 500_1500_M1 0 8.4686e-04 static_value=5.9105e-04
I_0_1_5_3 500_1300_M1 0 0 pulse(3.7712e-04, 2.8992e-03, 3.9872e-10, 1.0815e-10, 1.6095e-10, 2.3787e-09, 1.2686e-08)
I_0_1_9_5_2 900_1500_M1 0 0 pwl(0.0000e+00 2.3694e-03 1.9301e-09 6.4061e-04 3.6679e-09 1.5147e-03 6.5953e-09 1.7959e-03 9.1509e-09 4.0941e-04 1.0773e-08 1.4467e-03 1.3631e-08 1.4395e-03 1.6447e-08 9.3827e-04) pwl_period=2.0528e-08
I_0_1_6_2 600_1200_M1 0 3.7763e-04 pulse(0, 1.3306e-03, 0, 0.2n, 0.2n, 3.7285e-09, 1.6972e-08)
I_0_1_5_3_2 500_1300_M1 0 1.9047e-04 pwl(0 0 2n 8.4213e-04 5n 1.8055e-03 8n 6.9811e-04) pwl_period=10n
I_0_1_9_4 900_1400_M1 0 1.3489e-03
I_0_1_9_5_3 900_1500_M1 0 3.2875e-04 static_value=5.1965e-04
I_0_1_9_2 900_1200_M1 0 0 pulse(3.3076e-04, 1.1379e-03, 1.2951e-09, 1.0506e-10, 2.6802e-10, 3.4706e-09, 1.1035e-08)
I_0_1_4_9 400_1900_M1 0 0 pwl(0.0000e+00 1.5890e-03 2.6574e-09 1.7683e-03 4.5284e-09 1.8345e-03 7.4593e-09 6.7521e-04 1.0076e-08 1.3454e-03 1.2043e-08 1.0889e-03) pwl_period=1.5773e-08
I_0_1_2_8 200_1800_M1 0 4.5551e-04 pulse(0, 1.3307e-03, 0, 0.2n, 0.2n, 3.2600e-09, 1.8816e-08)
I_0_1_5_1 500_1100_M1 0 1.7316e-04 pwl(0 0 2n 7.3235e-04 5n 1.6103e-03 8n 4.8949e-04) pwl_period=10n
I_0_1_5_5_2 500_1500_M1 0 5.4305e-04
I_0_1_5_3_3 500_1300_M1 0 8.9567e-04 static_value=3.0910e-04
I_0_1_6_2_2 600_1200_M1 0 0 pulse(1.0606e-04, 2.5957e-03, 6.8068e-10, 4.5213e-10, 3.8047e-10, 2.8288e-09, 8.0711e-09)
I_0_1_2_8_2 200_1800_M1 0 0 pwl(0.0000e+00 2.1403e-04 2.4401e-09 1.2214e-03 4.9565e-09 1.7265e-03 7.2483e-09 1.2271e-03 9.8342e-09 2.3263e-04) pwl_period=1.2969e-08
I_0_1_0_3 0_1300_M1 0 2.9186e-04 pulse(0, 1.0816e-03, 0, 0.2n, 0.2n, 4.4198e-09, 1.5309e-08)
I_0_1_4_3 400_1300_M1 0 2.2765e-04 pwl(0 0 2n 8.7297e-04 5n 1.3308e-03 8n 6.5143e-04) pwl_period=10n
I_0_1_3_4 300_1400_M1 0 9.0637e-04
I_0_1_6_8 600_1800_M1 0 4.7598e-04 static_value=2.7239e-04
I_0_1_7_7 700_1700_M1 0 0 pulse(9.6292e-05, 1.2391e-03, 1.0717e-09, 4.0488e-10, 1.7406e-10, 2.6492e-09, 1.1389e-08)
I_0_1_8_6 800_1600_M1 0 0 pwl(0.0000e+00 2.4415e-03 2.0493e-09 7.0750e-04 3.2503e-09 4.8529e-04 4.7053e-09 4.4860e-04 5.7336e-09 1.3353e-03 7.2822e-09 2.4357e-03 9.3889e-09 1.7435e-03 1.0641e-08 2.1712e-03) pwl_period=1.4496e-08
I_0_1_6_9 600_1900_M1 0 3.7222e-04 pulse(0, 9.6940e-04, 0, 0.2n, 0.2n, 4.3214e-09, 1.1844e-08)
I_0_1_8_5 800_1500_M1 0 1.1541e-04 pwl(0 0 2n 9.7053e-04 5n 1.4777e-03 8n 7.1106e-04) pwl_period=10n
I_0_1_0_3_2 0_1300_M1 0 1.1011e-03

* Tile 0_1 summary:
*   Total current sources: 25
*   With static current: 17
*   With waveforms: 16
*   Overlapping nodes: 8
