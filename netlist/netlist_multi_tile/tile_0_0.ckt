* Tile 0_0 netlist
* Multi-layer routing with R, C elements
* Includes ground caps, coupling caps, and decaps

* ========== Layer M1 ==========
* Horizontal resistors (R=8 Ohm)
R_h_M1_0_0 0_0_M1 100_0_M1 8
R_h_M1_1_0 100_0_M1 200_0_M1 8
R_h_M1_2_0 200_0_M1 300_0_M1 8
R_h_M1_3_0 300_0_M1 400_0_M1 8
R_h_M1_4_0 400_0_M1 500_0_M1 8
R_h_M1_5_0 500_0_M1 600_0_M1 8
R_h_M1_6_0 600_0_M1 700_0_M1 8
R_h_M1_7_0 700_0_M1 800_0_M1 8
R_h_M1_8_0 800_0_M1 900_0_M1 8
R_h_M1_0_1 0_100_M1 100_100_M1 8
R_h_M1_1_1 100_100_M1 200_100_M1 8
R_h_M1_2_1 200_100_M1 300_100_M1 8
R_h_M1_3_1 300_100_M1 400_100_M1 8
R_h_M1_4_1 400_100_M1 500_100_M1 8
R_h_M1_5_1 500_100_M1 600_100_M1 8
R_h_M1_6_1 600_100_M1 700_100_M1 8
R_h_M1_7_1 700_100_M1 800_100_M1 8
R_h_M1_8_1 800_100_M1 900_100_M1 8
R_h_M1_0_2 0_200_M1 100_200_M1 8
R_h_M1_1_2 100_200_M1 200_200_M1 8
R_h_M1_2_2 200_200_M1 300_200_M1 8
R_h_M1_3_2 300_200_M1 400_200_M1 8
R_h_M1_4_2 400_200_M1 500_200_M1 8
R_h_M1_5_2 500_200_M1 600_200_M1 8
R_h_M1_6_2 600_200_M1 700_200_M1 8
R_h_M1_7_2 700_200_M1 800_200_M1 8
R_h_M1_8_2 800_200_M1 900_200_M1 8
R_h_M1_0_3 0_300_M1 100_300_M1 8
R_h_M1_1_3 100_300_M1 200_300_M1 8
R_h_M1_2_3 200_300_M1 300_300_M1 8
R_h_M1_3_3 300_300_M1 400_300_M1 8
R_h_M1_4_3 400_300_M1 500_300_M1 8
R_h_M1_5_3 500_300_M1 600_300_M1 8
R_h_M1_6_3 600_300_M1 700_300_M1 8
R_h_M1_7_3 700_300_M1 800_300_M1 8
R_h_M1_8_3 800_300_M1 900_300_M1 8
R_h_M1_0_4 0_400_M1 100_400_M1 8
R_h_M1_1_4 100_400_M1 200_400_M1 8
R_h_M1_2_4 200_400_M1 300_400_M1 8
R_h_M1_3_4 300_400_M1 400_400_M1 8
R_h_M1_4_4 400_400_M1 500_400_M1 8
R_h_M1_5_4 500_400_M1 600_400_M1 8
R_h_M1_6_4 600_400_M1 700_400_M1 8
R_h_M1_7_4 700_400_M1 800_400_M1 8
R_h_M1_8_4 800_400_M1 900_400_M1 8
R_h_M1_0_5 0_500_M1 100_500_M1 8
R_h_M1_1_5 100_500_M1 200_500_M1 8
R_h_M1_2_5 200_500_M1 300_500_M1 8
R_h_M1_3_5 300_500_M1 400_500_M1 8
R_h_M1_4_5 400_500_M1 500_500_M1 8
R_h_M1_5_5 500_500_M1 600_500_M1 8
R_h_M1_6_5 600_500_M1 700_500_M1 8
R_h_M1_7_5 700_500_M1 800_500_M1 8
R_h_M1_8_5 800_500_M1 900_500_M1 8
R_h_M1_0_6 0_600_M1 100_600_M1 8
R_h_M1_1_6 100_600_M1 200_600_M1 8
R_h_M1_2_6 200_600_M1 300_600_M1 8
R_h_M1_3_6 300_600_M1 400_600_M1 8
R_h_M1_4_6 400_600_M1 500_600_M1 8
R_h_M1_5_6 500_600_M1 600_600_M1 8
R_h_M1_6_6 600_600_M1 700_600_M1 8
R_h_M1_7_6 700_600_M1 800_600_M1 8
R_h_M1_8_6 800_600_M1 900_600_M1 8
R_h_M1_0_7 0_700_M1 100_700_M1 8
R_h_M1_1_7 100_700_M1 200_700_M1 8
R_h_M1_2_7 200_700_M1 300_700_M1 8
R_h_M1_3_7 300_700_M1 400_700_M1 8
R_h_M1_4_7 400_700_M1 500_700_M1 8
R_h_M1_5_7 500_700_M1 600_700_M1 8
R_h_M1_6_7 600_700_M1 700_700_M1 8
R_h_M1_7_7 700_700_M1 800_700_M1 8
R_h_M1_8_7 800_700_M1 900_700_M1 8
R_h_M1_0_8 0_800_M1 100_800_M1 8
R_h_M1_1_8 100_800_M1 200_800_M1 8
R_h_M1_2_8 200_800_M1 300_800_M1 8
R_h_M1_3_8 300_800_M1 400_800_M1 8
R_h_M1_4_8 400_800_M1 500_800_M1 8
R_h_M1_5_8 500_800_M1 600_800_M1 8
R_h_M1_6_8 600_800_M1 700_800_M1 8
R_h_M1_7_8 700_800_M1 800_800_M1 8
R_h_M1_8_8 800_800_M1 900_800_M1 8
R_h_M1_0_9 0_900_M1 100_900_M1 8
R_h_M1_1_9 100_900_M1 200_900_M1 8
R_h_M1_2_9 200_900_M1 300_900_M1 8
R_h_M1_3_9 300_900_M1 400_900_M1 8
R_h_M1_4_9 400_900_M1 500_900_M1 8
R_h_M1_5_9 500_900_M1 600_900_M1 8
R_h_M1_6_9 600_900_M1 700_900_M1 8
R_h_M1_7_9 700_900_M1 800_900_M1 8
R_h_M1_8_9 800_900_M1 900_900_M1 8
* Vertical resistors (R=10 Ohm)
R_v_M1_0_0 0_0_M1 0_100_M1 10
R_v_M1_1_0 100_0_M1 100_100_M1 10
R_v_M1_2_0 200_0_M1 200_100_M1 10
R_v_M1_3_0 300_0_M1 300_100_M1 10
R_v_M1_4_0 400_0_M1 400_100_M1 10
R_v_M1_5_0 500_0_M1 500_100_M1 10
R_v_M1_6_0 600_0_M1 600_100_M1 10
R_v_M1_7_0 700_0_M1 700_100_M1 10
R_v_M1_8_0 800_0_M1 800_100_M1 10
R_v_M1_9_0 900_0_M1 900_100_M1 10
R_v_M1_0_1 0_100_M1 0_200_M1 10
R_v_M1_1_1 100_100_M1 100_200_M1 10
R_v_M1_2_1 200_100_M1 200_200_M1 10
R_v_M1_3_1 300_100_M1 300_200_M1 10
R_v_M1_4_1 400_100_M1 400_200_M1 10
R_v_M1_5_1 500_100_M1 500_200_M1 10
R_v_M1_6_1 600_100_M1 600_200_M1 10
R_v_M1_7_1 700_100_M1 700_200_M1 10
R_v_M1_8_1 800_100_M1 800_200_M1 10
R_v_M1_9_1 900_100_M1 900_200_M1 10
R_v_M1_0_2 0_200_M1 0_300_M1 10
R_v_M1_1_2 100_200_M1 100_300_M1 10
R_v_M1_2_2 200_200_M1 200_300_M1 10
R_v_M1_3_2 300_200_M1 300_300_M1 10
R_v_M1_4_2 400_200_M1 400_300_M1 10
R_v_M1_5_2 500_200_M1 500_300_M1 10
R_v_M1_6_2 600_200_M1 600_300_M1 10
R_v_M1_7_2 700_200_M1 700_300_M1 10
R_v_M1_8_2 800_200_M1 800_300_M1 10
R_v_M1_9_2 900_200_M1 900_300_M1 10
R_v_M1_0_3 0_300_M1 0_400_M1 10
R_v_M1_1_3 100_300_M1 100_400_M1 10
R_v_M1_2_3 200_300_M1 200_400_M1 10
R_v_M1_3_3 300_300_M1 300_400_M1 10
R_v_M1_4_3 400_300_M1 400_400_M1 10
R_v_M1_5_3 500_300_M1 500_400_M1 10
R_v_M1_6_3 600_300_M1 600_400_M1 10
R_v_M1_7_3 700_300_M1 700_400_M1 10
R_v_M1_8_3 800_300_M1 800_400_M1 10
R_v_M1_9_3 900_300_M1 900_400_M1 10
R_v_M1_0_4 0_400_M1 0_500_M1 10
R_v_M1_1_4 100_400_M1 100_500_M1 10
R_v_M1_2_4 200_400_M1 200_500_M1 10
R_v_M1_3_4 300_400_M1 300_500_M1 10
R_v_M1_4_4 400_400_M1 400_500_M1 10
R_v_M1_5_4 500_400_M1 500_500_M1 10
R_v_M1_6_4 600_400_M1 600_500_M1 10
R_v_M1_7_4 700_400_M1 700_500_M1 10
R_v_M1_8_4 800_400_M1 800_500_M1 10
R_v_M1_9_4 900_400_M1 900_500_M1 10
R_v_M1_0_5 0_500_M1 0_600_M1 10
R_v_M1_1_5 100_500_M1 100_600_M1 10
R_v_M1_2_5 200_500_M1 200_600_M1 10
R_v_M1_3_5 300_500_M1 300_600_M1 10
R_v_M1_4_5 400_500_M1 400_600_M1 10
R_v_M1_5_5 500_500_M1 500_600_M1 10
R_v_M1_6_5 600_500_M1 600_600_M1 10
R_v_M1_7_5 700_500_M1 700_600_M1 10
R_v_M1_8_5 800_500_M1 800_600_M1 10
R_v_M1_9_5 900_500_M1 900_600_M1 10
R_v_M1_0_6 0_600_M1 0_700_M1 10
R_v_M1_1_6 100_600_M1 100_700_M1 10
R_v_M1_2_6 200_600_M1 200_700_M1 10
R_v_M1_3_6 300_600_M1 300_700_M1 10
R_v_M1_4_6 400_600_M1 400_700_M1 10
R_v_M1_5_6 500_600_M1 500_700_M1 10
R_v_M1_6_6 600_600_M1 600_700_M1 10
R_v_M1_7_6 700_600_M1 700_700_M1 10
R_v_M1_8_6 800_600_M1 800_700_M1 10
R_v_M1_9_6 900_600_M1 900_700_M1 10
R_v_M1_0_7 0_700_M1 0_800_M1 10
R_v_M1_1_7 100_700_M1 100_800_M1 10
R_v_M1_2_7 200_700_M1 200_800_M1 10
R_v_M1_3_7 300_700_M1 300_800_M1 10
R_v_M1_4_7 400_700_M1 400_800_M1 10
R_v_M1_5_7 500_700_M1 500_800_M1 10
R_v_M1_6_7 600_700_M1 600_800_M1 10
R_v_M1_7_7 700_700_M1 700_800_M1 10
R_v_M1_8_7 800_700_M1 800_800_M1 10
R_v_M1_9_7 900_700_M1 900_800_M1 10
R_v_M1_0_8 0_800_M1 0_900_M1 10
R_v_M1_1_8 100_800_M1 100_900_M1 10
R_v_M1_2_8 200_800_M1 200_900_M1 10
R_v_M1_3_8 300_800_M1 300_900_M1 10
R_v_M1_4_8 400_800_M1 400_900_M1 10
R_v_M1_5_8 500_800_M1 500_900_M1 10
R_v_M1_6_8 600_800_M1 600_900_M1 10
R_v_M1_7_8 700_800_M1 700_900_M1 10
R_v_M1_8_8 800_800_M1 800_900_M1 10
R_v_M1_9_8 900_800_M1 900_900_M1 10
* Ground capacitors (C=5.0 fF)
C_g_M1_0_0 0_0_M1 0 5e-15
C_g_M1_1_0 100_0_M1 0 5e-15
C_g_M1_2_0 200_0_M1 0 5e-15
C_g_M1_3_0 300_0_M1 0 5e-15
C_g_M1_4_0 400_0_M1 0 5e-15
C_g_M1_5_0 500_0_M1 0 5e-15
C_g_M1_6_0 600_0_M1 0 5e-15
C_g_M1_7_0 700_0_M1 0 5e-15
C_g_M1_8_0 800_0_M1 0 5e-15
C_g_M1_9_0 900_0_M1 0 5e-15
C_g_M1_0_1 0_100_M1 0 5e-15
C_g_M1_1_1 100_100_M1 0 5e-15
C_g_M1_2_1 200_100_M1 0 5e-15
C_g_M1_3_1 300_100_M1 0 5e-15
C_g_M1_4_1 400_100_M1 0 5e-15
C_g_M1_5_1 500_100_M1 0 5e-15
C_g_M1_6_1 600_100_M1 0 5e-15
C_g_M1_7_1 700_100_M1 0 5e-15
C_g_M1_8_1 800_100_M1 0 5e-15
C_g_M1_9_1 900_100_M1 0 5e-15
C_g_M1_0_2 0_200_M1 0 5e-15
C_g_M1_1_2 100_200_M1 0 5e-15
C_g_M1_2_2 200_200_M1 0 5e-15
C_g_M1_3_2 300_200_M1 0 5e-15
C_g_M1_4_2 400_200_M1 0 5e-15
C_g_M1_5_2 500_200_M1 0 5e-15
C_g_M1_6_2 600_200_M1 0 5e-15
C_g_M1_7_2 700_200_M1 0 5e-15
C_g_M1_8_2 800_200_M1 0 5e-15
C_g_M1_9_2 900_200_M1 0 5e-15
C_g_M1_0_3 0_300_M1 0 5e-15
C_g_M1_1_3 100_300_M1 0 5e-15
C_g_M1_2_3 200_300_M1 0 5e-15
C_g_M1_3_3 300_300_M1 0 5e-15
C_g_M1_4_3 400_300_M1 0 5e-15
C_g_M1_5_3 500_300_M1 0 5e-15
C_g_M1_6_3 600_300_M1 0 5e-15
C_g_M1_7_3 700_300_M1 0 5e-15
C_g_M1_8_3 800_300_M1 0 5e-15
C_g_M1_9_3 900_300_M1 0 5e-15
C_g_M1_0_4 0_400_M1 0 5e-15
C_g_M1_1_4 100_400_M1 0 5e-15
C_g_M1_2_4 200_400_M1 0 5e-15
C_g_M1_3_4 300_400_M1 0 5e-15
C_g_M1_4_4 400_400_M1 0 5e-15
C_g_M1_5_4 500_400_M1 0 5e-15
C_g_M1_6_4 600_400_M1 0 5e-15
C_g_M1_7_4 700_400_M1 0 5e-15
C_g_M1_8_4 800_400_M1 0 5e-15
C_g_M1_9_4 900_400_M1 0 5e-15
C_g_M1_0_5 0_500_M1 0 5e-15
C_g_M1_1_5 100_500_M1 0 5e-15
C_g_M1_2_5 200_500_M1 0 5e-15
C_g_M1_3_5 300_500_M1 0 5e-15
C_g_M1_4_5 400_500_M1 0 5e-15
C_g_M1_5_5 500_500_M1 0 5e-15
C_g_M1_6_5 600_500_M1 0 5e-15
C_g_M1_7_5 700_500_M1 0 5e-15
C_g_M1_8_5 800_500_M1 0 5e-15
C_g_M1_9_5 900_500_M1 0 5e-15
C_g_M1_0_6 0_600_M1 0 5e-15
C_g_M1_1_6 100_600_M1 0 5e-15
C_g_M1_2_6 200_600_M1 0 5e-15
C_g_M1_3_6 300_600_M1 0 5e-15
C_g_M1_4_6 400_600_M1 0 5e-15
C_g_M1_5_6 500_600_M1 0 5e-15
C_g_M1_6_6 600_600_M1 0 5e-15
C_g_M1_7_6 700_600_M1 0 5e-15
C_g_M1_8_6 800_600_M1 0 5e-15
C_g_M1_9_6 900_600_M1 0 5e-15
C_g_M1_0_7 0_700_M1 0 5e-15
C_g_M1_1_7 100_700_M1 0 5e-15
C_g_M1_2_7 200_700_M1 0 5e-15
C_g_M1_3_7 300_700_M1 0 5e-15
C_g_M1_4_7 400_700_M1 0 5e-15
C_g_M1_5_7 500_700_M1 0 5e-15
C_g_M1_6_7 600_700_M1 0 5e-15
C_g_M1_7_7 700_700_M1 0 5e-15
C_g_M1_8_7 800_700_M1 0 5e-15
C_g_M1_9_7 900_700_M1 0 5e-15
C_g_M1_0_8 0_800_M1 0 5e-15
C_g_M1_1_8 100_800_M1 0 5e-15
C_g_M1_2_8 200_800_M1 0 5e-15
C_g_M1_3_8 300_800_M1 0 5e-15
C_g_M1_4_8 400_800_M1 0 5e-15
C_g_M1_5_8 500_800_M1 0 5e-15
C_g_M1_6_8 600_800_M1 0 5e-15
C_g_M1_7_8 700_800_M1 0 5e-15
C_g_M1_8_8 800_800_M1 0 5e-15
C_g_M1_9_8 900_800_M1 0 5e-15
C_g_M1_0_9 0_900_M1 0 5e-15
C_g_M1_1_9 100_900_M1 0 5e-15
C_g_M1_2_9 200_900_M1 0 5e-15
C_g_M1_3_9 300_900_M1 0 5e-15
C_g_M1_4_9 400_900_M1 0 5e-15
C_g_M1_5_9 500_900_M1 0 5e-15
C_g_M1_6_9 600_900_M1 0 5e-15
C_g_M1_7_9 700_900_M1 0 5e-15
C_g_M1_8_9 800_900_M1 0 5e-15
C_g_M1_9_9 900_900_M1 0 5e-15
* Coupling capacitors (C=1.0 fF)
C_coup_M1_0_0 0_0_M1 100_0_M1 1e-15
C_coup_M1_2_0 200_0_M1 300_0_M1 1e-15
C_coup_M1_4_0 400_0_M1 500_0_M1 1e-15
C_coup_M1_6_0 600_0_M1 700_0_M1 1e-15
C_coup_M1_8_0 800_0_M1 900_0_M1 1e-15
C_coup_M1_0_1 0_100_M1 100_100_M1 1e-15
C_coup_M1_2_1 200_100_M1 300_100_M1 1e-15
C_coup_M1_4_1 400_100_M1 500_100_M1 1e-15
C_coup_M1_6_1 600_100_M1 700_100_M1 1e-15
C_coup_M1_8_1 800_100_M1 900_100_M1 1e-15
C_coup_M1_0_2 0_200_M1 100_200_M1 1e-15
C_coup_M1_2_2 200_200_M1 300_200_M1 1e-15
C_coup_M1_4_2 400_200_M1 500_200_M1 1e-15
C_coup_M1_6_2 600_200_M1 700_200_M1 1e-15
C_coup_M1_8_2 800_200_M1 900_200_M1 1e-15
C_coup_M1_0_3 0_300_M1 100_300_M1 1e-15
C_coup_M1_2_3 200_300_M1 300_300_M1 1e-15
C_coup_M1_4_3 400_300_M1 500_300_M1 1e-15
C_coup_M1_6_3 600_300_M1 700_300_M1 1e-15
C_coup_M1_8_3 800_300_M1 900_300_M1 1e-15
C_coup_M1_0_4 0_400_M1 100_400_M1 1e-15
C_coup_M1_2_4 200_400_M1 300_400_M1 1e-15
C_coup_M1_4_4 400_400_M1 500_400_M1 1e-15
C_coup_M1_6_4 600_400_M1 700_400_M1 1e-15
C_coup_M1_8_4 800_400_M1 900_400_M1 1e-15
C_coup_M1_0_5 0_500_M1 100_500_M1 1e-15
C_coup_M1_2_5 200_500_M1 300_500_M1 1e-15
C_coup_M1_4_5 400_500_M1 500_500_M1 1e-15
C_coup_M1_6_5 600_500_M1 700_500_M1 1e-15
C_coup_M1_8_5 800_500_M1 900_500_M1 1e-15
C_coup_M1_0_6 0_600_M1 100_600_M1 1e-15
C_coup_M1_2_6 200_600_M1 300_600_M1 1e-15
C_coup_M1_4_6 400_600_M1 500_600_M1 1e-15
C_coup_M1_6_6 600_600_M1 700_600_M1 1e-15
C_coup_M1_8_6 800_600_M1 900_600_M1 1e-15
C_coup_M1_0_7 0_700_M1 100_700_M1 1e-15
C_coup_M1_2_7 200_700_M1 300_700_M1 1e-15
C_coup_M1_4_7 400_700_M1 500_700_M1 1e-15
C_coup_M1_6_7 600_700_M1 700_700_M1 1e-15
C_coup_M1_8_7 800_700_M1 900_700_M1 1e-15
C_coup_M1_0_8 0_800_M1 100_800_M1 1e-15
C_coup_M1_2_8 200_800_M1 300_800_M1 1e-15
C_coup_M1_4_8 400_800_M1 500_800_M1 1e-15
C_coup_M1_6_8 600_800_M1 700_800_M1 1e-15
C_coup_M1_8_8 800_800_M1 900_800_M1 1e-15
C_coup_M1_0_9 0_900_M1 100_900_M1 1e-15
C_coup_M1_2_9 200_900_M1 300_900_M1 1e-15
C_coup_M1_4_9 400_900_M1 500_900_M1 1e-15
C_coup_M1_6_9 600_900_M1 700_900_M1 1e-15
C_coup_M1_8_9 800_900_M1 900_900_M1 1e-15

* ========== Layer M2 ==========
* Horizontal resistors (R=5 Ohm)
R_h_M2_0_0 0_0_M2 100_0_M2 5
R_h_M2_1_0 100_0_M2 200_0_M2 5
R_h_M2_2_0 200_0_M2 300_0_M2 5
R_h_M2_3_0 300_0_M2 400_0_M2 5
R_h_M2_4_0 400_0_M2 500_0_M2 5
R_h_M2_5_0 500_0_M2 600_0_M2 5
R_h_M2_6_0 600_0_M2 700_0_M2 5
R_h_M2_7_0 700_0_M2 800_0_M2 5
R_h_M2_8_0 800_0_M2 900_0_M2 5
R_h_M2_0_1 0_100_M2 100_100_M2 5
R_h_M2_1_1 100_100_M2 200_100_M2 5
R_h_M2_2_1 200_100_M2 300_100_M2 5
R_h_M2_3_1 300_100_M2 400_100_M2 5
R_h_M2_4_1 400_100_M2 500_100_M2 5
R_h_M2_5_1 500_100_M2 600_100_M2 5
R_h_M2_6_1 600_100_M2 700_100_M2 5
R_h_M2_7_1 700_100_M2 800_100_M2 5
R_h_M2_8_1 800_100_M2 900_100_M2 5
R_h_M2_0_2 0_200_M2 100_200_M2 5
R_h_M2_1_2 100_200_M2 200_200_M2 5
R_h_M2_2_2 200_200_M2 300_200_M2 5
R_h_M2_3_2 300_200_M2 400_200_M2 5
R_h_M2_4_2 400_200_M2 500_200_M2 5
R_h_M2_5_2 500_200_M2 600_200_M2 5
R_h_M2_6_2 600_200_M2 700_200_M2 5
R_h_M2_7_2 700_200_M2 800_200_M2 5
R_h_M2_8_2 800_200_M2 900_200_M2 5
R_h_M2_0_3 0_300_M2 100_300_M2 5
R_h_M2_1_3 100_300_M2 200_300_M2 5
R_h_M2_2_3 200_300_M2 300_300_M2 5
R_h_M2_3_3 300_300_M2 400_300_M2 5
R_h_M2_4_3 400_300_M2 500_300_M2 5
R_h_M2_5_3 500_300_M2 600_300_M2 5
R_h_M2_6_3 600_300_M2 700_300_M2 5
R_h_M2_7_3 700_300_M2 800_300_M2 5
R_h_M2_8_3 800_300_M2 900_300_M2 5
R_h_M2_0_4 0_400_M2 100_400_M2 5
R_h_M2_1_4 100_400_M2 200_400_M2 5
R_h_M2_2_4 200_400_M2 300_400_M2 5
R_h_M2_3_4 300_400_M2 400_400_M2 5
R_h_M2_4_4 400_400_M2 500_400_M2 5
R_h_M2_5_4 500_400_M2 600_400_M2 5
R_h_M2_6_4 600_400_M2 700_400_M2 5
R_h_M2_7_4 700_400_M2 800_400_M2 5
R_h_M2_8_4 800_400_M2 900_400_M2 5
R_h_M2_0_5 0_500_M2 100_500_M2 5
R_h_M2_1_5 100_500_M2 200_500_M2 5
R_h_M2_2_5 200_500_M2 300_500_M2 5
R_h_M2_3_5 300_500_M2 400_500_M2 5
R_h_M2_4_5 400_500_M2 500_500_M2 5
R_h_M2_5_5 500_500_M2 600_500_M2 5
R_h_M2_6_5 600_500_M2 700_500_M2 5
R_h_M2_7_5 700_500_M2 800_500_M2 5
R_h_M2_8_5 800_500_M2 900_500_M2 5
R_h_M2_0_6 0_600_M2 100_600_M2 5
R_h_M2_1_6 100_600_M2 200_600_M2 5
R_h_M2_2_6 200_600_M2 300_600_M2 5
R_h_M2_3_6 300_600_M2 400_600_M2 5
R_h_M2_4_6 400_600_M2 500_600_M2 5
R_h_M2_5_6 500_600_M2 600_600_M2 5
R_h_M2_6_6 600_600_M2 700_600_M2 5
R_h_M2_7_6 700_600_M2 800_600_M2 5
R_h_M2_8_6 800_600_M2 900_600_M2 5
R_h_M2_0_7 0_700_M2 100_700_M2 5
R_h_M2_1_7 100_700_M2 200_700_M2 5
R_h_M2_2_7 200_700_M2 300_700_M2 5
R_h_M2_3_7 300_700_M2 400_700_M2 5
R_h_M2_4_7 400_700_M2 500_700_M2 5
R_h_M2_5_7 500_700_M2 600_700_M2 5
R_h_M2_6_7 600_700_M2 700_700_M2 5
R_h_M2_7_7 700_700_M2 800_700_M2 5
R_h_M2_8_7 800_700_M2 900_700_M2 5
R_h_M2_0_8 0_800_M2 100_800_M2 5
R_h_M2_1_8 100_800_M2 200_800_M2 5
R_h_M2_2_8 200_800_M2 300_800_M2 5
R_h_M2_3_8 300_800_M2 400_800_M2 5
R_h_M2_4_8 400_800_M2 500_800_M2 5
R_h_M2_5_8 500_800_M2 600_800_M2 5
R_h_M2_6_8 600_800_M2 700_800_M2 5
R_h_M2_7_8 700_800_M2 800_800_M2 5
R_h_M2_8_8 800_800_M2 900_800_M2 5
R_h_M2_0_9 0_900_M2 100_900_M2 5
R_h_M2_1_9 100_900_M2 200_900_M2 5
R_h_M2_2_9 200_900_M2 300_900_M2 5
R_h_M2_3_9 300_900_M2 400_900_M2 5
R_h_M2_4_9 400_900_M2 500_900_M2 5
R_h_M2_5_9 500_900_M2 600_900_M2 5
R_h_M2_6_9 600_900_M2 700_900_M2 5
R_h_M2_7_9 700_900_M2 800_900_M2 5
R_h_M2_8_9 800_900_M2 900_900_M2 5
* Vertical resistors (R=6 Ohm)
R_v_M2_0_0 0_0_M2 0_100_M2 6
R_v_M2_1_0 100_0_M2 100_100_M2 6
R_v_M2_2_0 200_0_M2 200_100_M2 6
R_v_M2_3_0 300_0_M2 300_100_M2 6
R_v_M2_4_0 400_0_M2 400_100_M2 6
R_v_M2_5_0 500_0_M2 500_100_M2 6
R_v_M2_6_0 600_0_M2 600_100_M2 6
R_v_M2_7_0 700_0_M2 700_100_M2 6
R_v_M2_8_0 800_0_M2 800_100_M2 6
R_v_M2_9_0 900_0_M2 900_100_M2 6
R_v_M2_0_1 0_100_M2 0_200_M2 6
R_v_M2_1_1 100_100_M2 100_200_M2 6
R_v_M2_2_1 200_100_M2 200_200_M2 6
R_v_M2_3_1 300_100_M2 300_200_M2 6
R_v_M2_4_1 400_100_M2 400_200_M2 6
R_v_M2_5_1 500_100_M2 500_200_M2 6
R_v_M2_6_1 600_100_M2 600_200_M2 6
R_v_M2_7_1 700_100_M2 700_200_M2 6
R_v_M2_8_1 800_100_M2 800_200_M2 6
R_v_M2_9_1 900_100_M2 900_200_M2 6
R_v_M2_0_2 0_200_M2 0_300_M2 6
R_v_M2_1_2 100_200_M2 100_300_M2 6
R_v_M2_2_2 200_200_M2 200_300_M2 6
R_v_M2_3_2 300_200_M2 300_300_M2 6
R_v_M2_4_2 400_200_M2 400_300_M2 6
R_v_M2_5_2 500_200_M2 500_300_M2 6
R_v_M2_6_2 600_200_M2 600_300_M2 6
R_v_M2_7_2 700_200_M2 700_300_M2 6
R_v_M2_8_2 800_200_M2 800_300_M2 6
R_v_M2_9_2 900_200_M2 900_300_M2 6
R_v_M2_0_3 0_300_M2 0_400_M2 6
R_v_M2_1_3 100_300_M2 100_400_M2 6
R_v_M2_2_3 200_300_M2 200_400_M2 6
R_v_M2_3_3 300_300_M2 300_400_M2 6
R_v_M2_4_3 400_300_M2 400_400_M2 6
R_v_M2_5_3 500_300_M2 500_400_M2 6
R_v_M2_6_3 600_300_M2 600_400_M2 6
R_v_M2_7_3 700_300_M2 700_400_M2 6
R_v_M2_8_3 800_300_M2 800_400_M2 6
R_v_M2_9_3 900_300_M2 900_400_M2 6
R_v_M2_0_4 0_400_M2 0_500_M2 6
R_v_M2_1_4 100_400_M2 100_500_M2 6
R_v_M2_2_4 200_400_M2 200_500_M2 6
R_v_M2_3_4 300_400_M2 300_500_M2 6
R_v_M2_4_4 400_400_M2 400_500_M2 6
R_v_M2_5_4 500_400_M2 500_500_M2 6
R_v_M2_6_4 600_400_M2 600_500_M2 6
R_v_M2_7_4 700_400_M2 700_500_M2 6
R_v_M2_8_4 800_400_M2 800_500_M2 6
R_v_M2_9_4 900_400_M2 900_500_M2 6
R_v_M2_0_5 0_500_M2 0_600_M2 6
R_v_M2_1_5 100_500_M2 100_600_M2 6
R_v_M2_2_5 200_500_M2 200_600_M2 6
R_v_M2_3_5 300_500_M2 300_600_M2 6
R_v_M2_4_5 400_500_M2 400_600_M2 6
R_v_M2_5_5 500_500_M2 500_600_M2 6
R_v_M2_6_5 600_500_M2 600_600_M2 6
R_v_M2_7_5 700_500_M2 700_600_M2 6
R_v_M2_8_5 800_500_M2 800_600_M2 6
R_v_M2_9_5 900_500_M2 900_600_M2 6
R_v_M2_0_6 0_600_M2 0_700_M2 6
R_v_M2_1_6 100_600_M2 100_700_M2 6
R_v_M2_2_6 200_600_M2 200_700_M2 6
R_v_M2_3_6 300_600_M2 300_700_M2 6
R_v_M2_4_6 400_600_M2 400_700_M2 6
R_v_M2_5_6 500_600_M2 500_700_M2 6
R_v_M2_6_6 600_600_M2 600_700_M2 6
R_v_M2_7_6 700_600_M2 700_700_M2 6
R_v_M2_8_6 800_600_M2 800_700_M2 6
R_v_M2_9_6 900_600_M2 900_700_M2 6
R_v_M2_0_7 0_700_M2 0_800_M2 6
R_v_M2_1_7 100_700_M2 100_800_M2 6
R_v_M2_2_7 200_700_M2 200_800_M2 6
R_v_M2_3_7 300_700_M2 300_800_M2 6
R_v_M2_4_7 400_700_M2 400_800_M2 6
R_v_M2_5_7 500_700_M2 500_800_M2 6
R_v_M2_6_7 600_700_M2 600_800_M2 6
R_v_M2_7_7 700_700_M2 700_800_M2 6
R_v_M2_8_7 800_700_M2 800_800_M2 6
R_v_M2_9_7 900_700_M2 900_800_M2 6
R_v_M2_0_8 0_800_M2 0_900_M2 6
R_v_M2_1_8 100_800_M2 100_900_M2 6
R_v_M2_2_8 200_800_M2 200_900_M2 6
R_v_M2_3_8 300_800_M2 300_900_M2 6
R_v_M2_4_8 400_800_M2 400_900_M2 6
R_v_M2_5_8 500_800_M2 500_900_M2 6
R_v_M2_6_8 600_800_M2 600_900_M2 6
R_v_M2_7_8 700_800_M2 700_900_M2 6
R_v_M2_8_8 800_800_M2 800_900_M2 6
R_v_M2_9_8 900_800_M2 900_900_M2 6
* Ground capacitors (C=3.0 fF)
C_g_M2_0_0 0_0_M2 0 3e-15
C_g_M2_1_0 100_0_M2 0 3e-15
C_g_M2_2_0 200_0_M2 0 3e-15
C_g_M2_3_0 300_0_M2 0 3e-15
C_g_M2_4_0 400_0_M2 0 3e-15
C_g_M2_5_0 500_0_M2 0 3e-15
C_g_M2_6_0 600_0_M2 0 3e-15
C_g_M2_7_0 700_0_M2 0 3e-15
C_g_M2_8_0 800_0_M2 0 3e-15
C_g_M2_9_0 900_0_M2 0 3e-15
C_g_M2_0_1 0_100_M2 0 3e-15
C_g_M2_1_1 100_100_M2 0 3e-15
C_g_M2_2_1 200_100_M2 0 3e-15
C_g_M2_3_1 300_100_M2 0 3e-15
C_g_M2_4_1 400_100_M2 0 3e-15
C_g_M2_5_1 500_100_M2 0 3e-15
C_g_M2_6_1 600_100_M2 0 3e-15
C_g_M2_7_1 700_100_M2 0 3e-15
C_g_M2_8_1 800_100_M2 0 3e-15
C_g_M2_9_1 900_100_M2 0 3e-15
C_g_M2_0_2 0_200_M2 0 3e-15
C_g_M2_1_2 100_200_M2 0 3e-15
C_g_M2_2_2 200_200_M2 0 3e-15
C_g_M2_3_2 300_200_M2 0 3e-15
C_g_M2_4_2 400_200_M2 0 3e-15
C_g_M2_5_2 500_200_M2 0 3e-15
C_g_M2_6_2 600_200_M2 0 3e-15
C_g_M2_7_2 700_200_M2 0 3e-15
C_g_M2_8_2 800_200_M2 0 3e-15
C_g_M2_9_2 900_200_M2 0 3e-15
C_g_M2_0_3 0_300_M2 0 3e-15
C_g_M2_1_3 100_300_M2 0 3e-15
C_g_M2_2_3 200_300_M2 0 3e-15
C_g_M2_3_3 300_300_M2 0 3e-15
C_g_M2_4_3 400_300_M2 0 3e-15
C_g_M2_5_3 500_300_M2 0 3e-15
C_g_M2_6_3 600_300_M2 0 3e-15
C_g_M2_7_3 700_300_M2 0 3e-15
C_g_M2_8_3 800_300_M2 0 3e-15
C_g_M2_9_3 900_300_M2 0 3e-15
C_g_M2_0_4 0_400_M2 0 3e-15
C_g_M2_1_4 100_400_M2 0 3e-15
C_g_M2_2_4 200_400_M2 0 3e-15
C_g_M2_3_4 300_400_M2 0 3e-15
C_g_M2_4_4 400_400_M2 0 3e-15
C_g_M2_5_4 500_400_M2 0 3e-15
C_g_M2_6_4 600_400_M2 0 3e-15
C_g_M2_7_4 700_400_M2 0 3e-15
C_g_M2_8_4 800_400_M2 0 3e-15
C_g_M2_9_4 900_400_M2 0 3e-15
C_g_M2_0_5 0_500_M2 0 3e-15
C_g_M2_1_5 100_500_M2 0 3e-15
C_g_M2_2_5 200_500_M2 0 3e-15
C_g_M2_3_5 300_500_M2 0 3e-15
C_g_M2_4_5 400_500_M2 0 3e-15
C_g_M2_5_5 500_500_M2 0 3e-15
C_g_M2_6_5 600_500_M2 0 3e-15
C_g_M2_7_5 700_500_M2 0 3e-15
C_g_M2_8_5 800_500_M2 0 3e-15
C_g_M2_9_5 900_500_M2 0 3e-15
C_g_M2_0_6 0_600_M2 0 3e-15
C_g_M2_1_6 100_600_M2 0 3e-15
C_g_M2_2_6 200_600_M2 0 3e-15
C_g_M2_3_6 300_600_M2 0 3e-15
C_g_M2_4_6 400_600_M2 0 3e-15
C_g_M2_5_6 500_600_M2 0 3e-15
C_g_M2_6_6 600_600_M2 0 3e-15
C_g_M2_7_6 700_600_M2 0 3e-15
C_g_M2_8_6 800_600_M2 0 3e-15
C_g_M2_9_6 900_600_M2 0 3e-15
C_g_M2_0_7 0_700_M2 0 3e-15
C_g_M2_1_7 100_700_M2 0 3e-15
C_g_M2_2_7 200_700_M2 0 3e-15
C_g_M2_3_7 300_700_M2 0 3e-15
C_g_M2_4_7 400_700_M2 0 3e-15
C_g_M2_5_7 500_700_M2 0 3e-15
C_g_M2_6_7 600_700_M2 0 3e-15
C_g_M2_7_7 700_700_M2 0 3e-15
C_g_M2_8_7 800_700_M2 0 3e-15
C_g_M2_9_7 900_700_M2 0 3e-15
C_g_M2_0_8 0_800_M2 0 3e-15
C_g_M2_1_8 100_800_M2 0 3e-15
C_g_M2_2_8 200_800_M2 0 3e-15
C_g_M2_3_8 300_800_M2 0 3e-15
C_g_M2_4_8 400_800_M2 0 3e-15
C_g_M2_5_8 500_800_M2 0 3e-15
C_g_M2_6_8 600_800_M2 0 3e-15
C_g_M2_7_8 700_800_M2 0 3e-15
C_g_M2_8_8 800_800_M2 0 3e-15
C_g_M2_9_8 900_800_M2 0 3e-15
C_g_M2_0_9 0_900_M2 0 3e-15
C_g_M2_1_9 100_900_M2 0 3e-15
C_g_M2_2_9 200_900_M2 0 3e-15
C_g_M2_3_9 300_900_M2 0 3e-15
C_g_M2_4_9 400_900_M2 0 3e-15
C_g_M2_5_9 500_900_M2 0 3e-15
C_g_M2_6_9 600_900_M2 0 3e-15
C_g_M2_7_9 700_900_M2 0 3e-15
C_g_M2_8_9 800_900_M2 0 3e-15
C_g_M2_9_9 900_900_M2 0 3e-15
* Coupling capacitors (C=1.0 fF)
C_coup_M2_0_0 0_0_M2 100_0_M2 1e-15
C_coup_M2_2_0 200_0_M2 300_0_M2 1e-15
C_coup_M2_4_0 400_0_M2 500_0_M2 1e-15
C_coup_M2_6_0 600_0_M2 700_0_M2 1e-15
C_coup_M2_8_0 800_0_M2 900_0_M2 1e-15
C_coup_M2_0_1 0_100_M2 100_100_M2 1e-15
C_coup_M2_2_1 200_100_M2 300_100_M2 1e-15
C_coup_M2_4_1 400_100_M2 500_100_M2 1e-15
C_coup_M2_6_1 600_100_M2 700_100_M2 1e-15
C_coup_M2_8_1 800_100_M2 900_100_M2 1e-15
C_coup_M2_0_2 0_200_M2 100_200_M2 1e-15
C_coup_M2_2_2 200_200_M2 300_200_M2 1e-15
C_coup_M2_4_2 400_200_M2 500_200_M2 1e-15
C_coup_M2_6_2 600_200_M2 700_200_M2 1e-15
C_coup_M2_8_2 800_200_M2 900_200_M2 1e-15
C_coup_M2_0_3 0_300_M2 100_300_M2 1e-15
C_coup_M2_2_3 200_300_M2 300_300_M2 1e-15
C_coup_M2_4_3 400_300_M2 500_300_M2 1e-15
C_coup_M2_6_3 600_300_M2 700_300_M2 1e-15
C_coup_M2_8_3 800_300_M2 900_300_M2 1e-15
C_coup_M2_0_4 0_400_M2 100_400_M2 1e-15
C_coup_M2_2_4 200_400_M2 300_400_M2 1e-15
C_coup_M2_4_4 400_400_M2 500_400_M2 1e-15
C_coup_M2_6_4 600_400_M2 700_400_M2 1e-15
C_coup_M2_8_4 800_400_M2 900_400_M2 1e-15
C_coup_M2_0_5 0_500_M2 100_500_M2 1e-15
C_coup_M2_2_5 200_500_M2 300_500_M2 1e-15
C_coup_M2_4_5 400_500_M2 500_500_M2 1e-15
C_coup_M2_6_5 600_500_M2 700_500_M2 1e-15
C_coup_M2_8_5 800_500_M2 900_500_M2 1e-15
C_coup_M2_0_6 0_600_M2 100_600_M2 1e-15
C_coup_M2_2_6 200_600_M2 300_600_M2 1e-15
C_coup_M2_4_6 400_600_M2 500_600_M2 1e-15
C_coup_M2_6_6 600_600_M2 700_600_M2 1e-15
C_coup_M2_8_6 800_600_M2 900_600_M2 1e-15
C_coup_M2_0_7 0_700_M2 100_700_M2 1e-15
C_coup_M2_2_7 200_700_M2 300_700_M2 1e-15
C_coup_M2_4_7 400_700_M2 500_700_M2 1e-15
C_coup_M2_6_7 600_700_M2 700_700_M2 1e-15
C_coup_M2_8_7 800_700_M2 900_700_M2 1e-15
C_coup_M2_0_8 0_800_M2 100_800_M2 1e-15
C_coup_M2_2_8 200_800_M2 300_800_M2 1e-15
C_coup_M2_4_8 400_800_M2 500_800_M2 1e-15
C_coup_M2_6_8 600_800_M2 700_800_M2 1e-15
C_coup_M2_8_8 800_800_M2 900_800_M2 1e-15
C_coup_M2_0_9 0_900_M2 100_900_M2 1e-15
C_coup_M2_2_9 200_900_M2 300_900_M2 1e-15
C_coup_M2_4_9 400_900_M2 500_900_M2 1e-15
C_coup_M2_6_9 600_900_M2 700_900_M2 1e-15
C_coup_M2_8_9 800_900_M2 900_900_M2 1e-15

* ========== Layer M3 ==========
* Horizontal resistors (R=3 Ohm)
R_h_M3_0_0 0_0_M3 100_0_M3 3
R_h_M3_1_0 100_0_M3 200_0_M3 3
R_h_M3_2_0 200_0_M3 300_0_M3 3
R_h_M3_3_0 300_0_M3 400_0_M3 3
R_h_M3_4_0 400_0_M3 500_0_M3 3
R_h_M3_5_0 500_0_M3 600_0_M3 3
R_h_M3_6_0 600_0_M3 700_0_M3 3
R_h_M3_7_0 700_0_M3 800_0_M3 3
R_h_M3_8_0 800_0_M3 900_0_M3 3
R_h_M3_0_1 0_100_M3 100_100_M3 3
R_h_M3_1_1 100_100_M3 200_100_M3 3
R_h_M3_2_1 200_100_M3 300_100_M3 3
R_h_M3_3_1 300_100_M3 400_100_M3 3
R_h_M3_4_1 400_100_M3 500_100_M3 3
R_h_M3_5_1 500_100_M3 600_100_M3 3
R_h_M3_6_1 600_100_M3 700_100_M3 3
R_h_M3_7_1 700_100_M3 800_100_M3 3
R_h_M3_8_1 800_100_M3 900_100_M3 3
R_h_M3_0_2 0_200_M3 100_200_M3 3
R_h_M3_1_2 100_200_M3 200_200_M3 3
R_h_M3_2_2 200_200_M3 300_200_M3 3
R_h_M3_3_2 300_200_M3 400_200_M3 3
R_h_M3_4_2 400_200_M3 500_200_M3 3
R_h_M3_5_2 500_200_M3 600_200_M3 3
R_h_M3_6_2 600_200_M3 700_200_M3 3
R_h_M3_7_2 700_200_M3 800_200_M3 3
R_h_M3_8_2 800_200_M3 900_200_M3 3
R_h_M3_0_3 0_300_M3 100_300_M3 3
R_h_M3_1_3 100_300_M3 200_300_M3 3
R_h_M3_2_3 200_300_M3 300_300_M3 3
R_h_M3_3_3 300_300_M3 400_300_M3 3
R_h_M3_4_3 400_300_M3 500_300_M3 3
R_h_M3_5_3 500_300_M3 600_300_M3 3
R_h_M3_6_3 600_300_M3 700_300_M3 3
R_h_M3_7_3 700_300_M3 800_300_M3 3
R_h_M3_8_3 800_300_M3 900_300_M3 3
R_h_M3_0_4 0_400_M3 100_400_M3 3
R_h_M3_1_4 100_400_M3 200_400_M3 3
R_h_M3_2_4 200_400_M3 300_400_M3 3
R_h_M3_3_4 300_400_M3 400_400_M3 3
R_h_M3_4_4 400_400_M3 500_400_M3 3
R_h_M3_5_4 500_400_M3 600_400_M3 3
R_h_M3_6_4 600_400_M3 700_400_M3 3
R_h_M3_7_4 700_400_M3 800_400_M3 3
R_h_M3_8_4 800_400_M3 900_400_M3 3
R_h_M3_0_5 0_500_M3 100_500_M3 3
R_h_M3_1_5 100_500_M3 200_500_M3 3
R_h_M3_2_5 200_500_M3 300_500_M3 3
R_h_M3_3_5 300_500_M3 400_500_M3 3
R_h_M3_4_5 400_500_M3 500_500_M3 3
R_h_M3_5_5 500_500_M3 600_500_M3 3
R_h_M3_6_5 600_500_M3 700_500_M3 3
R_h_M3_7_5 700_500_M3 800_500_M3 3
R_h_M3_8_5 800_500_M3 900_500_M3 3
R_h_M3_0_6 0_600_M3 100_600_M3 3
R_h_M3_1_6 100_600_M3 200_600_M3 3
R_h_M3_2_6 200_600_M3 300_600_M3 3
R_h_M3_3_6 300_600_M3 400_600_M3 3
R_h_M3_4_6 400_600_M3 500_600_M3 3
R_h_M3_5_6 500_600_M3 600_600_M3 3
R_h_M3_6_6 600_600_M3 700_600_M3 3
R_h_M3_7_6 700_600_M3 800_600_M3 3
R_h_M3_8_6 800_600_M3 900_600_M3 3
R_h_M3_0_7 0_700_M3 100_700_M3 3
R_h_M3_1_7 100_700_M3 200_700_M3 3
R_h_M3_2_7 200_700_M3 300_700_M3 3
R_h_M3_3_7 300_700_M3 400_700_M3 3
R_h_M3_4_7 400_700_M3 500_700_M3 3
R_h_M3_5_7 500_700_M3 600_700_M3 3
R_h_M3_6_7 600_700_M3 700_700_M3 3
R_h_M3_7_7 700_700_M3 800_700_M3 3
R_h_M3_8_7 800_700_M3 900_700_M3 3
R_h_M3_0_8 0_800_M3 100_800_M3 3
R_h_M3_1_8 100_800_M3 200_800_M3 3
R_h_M3_2_8 200_800_M3 300_800_M3 3
R_h_M3_3_8 300_800_M3 400_800_M3 3
R_h_M3_4_8 400_800_M3 500_800_M3 3
R_h_M3_5_8 500_800_M3 600_800_M3 3
R_h_M3_6_8 600_800_M3 700_800_M3 3
R_h_M3_7_8 700_800_M3 800_800_M3 3
R_h_M3_8_8 800_800_M3 900_800_M3 3
R_h_M3_0_9 0_900_M3 100_900_M3 3
R_h_M3_1_9 100_900_M3 200_900_M3 3
R_h_M3_2_9 200_900_M3 300_900_M3 3
R_h_M3_3_9 300_900_M3 400_900_M3 3
R_h_M3_4_9 400_900_M3 500_900_M3 3
R_h_M3_5_9 500_900_M3 600_900_M3 3
R_h_M3_6_9 600_900_M3 700_900_M3 3
R_h_M3_7_9 700_900_M3 800_900_M3 3
R_h_M3_8_9 800_900_M3 900_900_M3 3
* Vertical resistors (R=4 Ohm)
R_v_M3_0_0 0_0_M3 0_100_M3 4
R_v_M3_1_0 100_0_M3 100_100_M3 4
R_v_M3_2_0 200_0_M3 200_100_M3 4
R_v_M3_3_0 300_0_M3 300_100_M3 4
R_v_M3_4_0 400_0_M3 400_100_M3 4
R_v_M3_5_0 500_0_M3 500_100_M3 4
R_v_M3_6_0 600_0_M3 600_100_M3 4
R_v_M3_7_0 700_0_M3 700_100_M3 4
R_v_M3_8_0 800_0_M3 800_100_M3 4
R_v_M3_9_0 900_0_M3 900_100_M3 4
R_v_M3_0_1 0_100_M3 0_200_M3 4
R_v_M3_1_1 100_100_M3 100_200_M3 4
R_v_M3_2_1 200_100_M3 200_200_M3 4
R_v_M3_3_1 300_100_M3 300_200_M3 4
R_v_M3_4_1 400_100_M3 400_200_M3 4
R_v_M3_5_1 500_100_M3 500_200_M3 4
R_v_M3_6_1 600_100_M3 600_200_M3 4
R_v_M3_7_1 700_100_M3 700_200_M3 4
R_v_M3_8_1 800_100_M3 800_200_M3 4
R_v_M3_9_1 900_100_M3 900_200_M3 4
R_v_M3_0_2 0_200_M3 0_300_M3 4
R_v_M3_1_2 100_200_M3 100_300_M3 4
R_v_M3_2_2 200_200_M3 200_300_M3 4
R_v_M3_3_2 300_200_M3 300_300_M3 4
R_v_M3_4_2 400_200_M3 400_300_M3 4
R_v_M3_5_2 500_200_M3 500_300_M3 4
R_v_M3_6_2 600_200_M3 600_300_M3 4
R_v_M3_7_2 700_200_M3 700_300_M3 4
R_v_M3_8_2 800_200_M3 800_300_M3 4
R_v_M3_9_2 900_200_M3 900_300_M3 4
R_v_M3_0_3 0_300_M3 0_400_M3 4
R_v_M3_1_3 100_300_M3 100_400_M3 4
R_v_M3_2_3 200_300_M3 200_400_M3 4
R_v_M3_3_3 300_300_M3 300_400_M3 4
R_v_M3_4_3 400_300_M3 400_400_M3 4
R_v_M3_5_3 500_300_M3 500_400_M3 4
R_v_M3_6_3 600_300_M3 600_400_M3 4
R_v_M3_7_3 700_300_M3 700_400_M3 4
R_v_M3_8_3 800_300_M3 800_400_M3 4
R_v_M3_9_3 900_300_M3 900_400_M3 4
R_v_M3_0_4 0_400_M3 0_500_M3 4
R_v_M3_1_4 100_400_M3 100_500_M3 4
R_v_M3_2_4 200_400_M3 200_500_M3 4
R_v_M3_3_4 300_400_M3 300_500_M3 4
R_v_M3_4_4 400_400_M3 400_500_M3 4
R_v_M3_5_4 500_400_M3 500_500_M3 4
R_v_M3_6_4 600_400_M3 600_500_M3 4
R_v_M3_7_4 700_400_M3 700_500_M3 4
R_v_M3_8_4 800_400_M3 800_500_M3 4
R_v_M3_9_4 900_400_M3 900_500_M3 4
R_v_M3_0_5 0_500_M3 0_600_M3 4
R_v_M3_1_5 100_500_M3 100_600_M3 4
R_v_M3_2_5 200_500_M3 200_600_M3 4
R_v_M3_3_5 300_500_M3 300_600_M3 4
R_v_M3_4_5 400_500_M3 400_600_M3 4
R_v_M3_5_5 500_500_M3 500_600_M3 4
R_v_M3_6_5 600_500_M3 600_600_M3 4
R_v_M3_7_5 700_500_M3 700_600_M3 4
R_v_M3_8_5 800_500_M3 800_600_M3 4
R_v_M3_9_5 900_500_M3 900_600_M3 4
R_v_M3_0_6 0_600_M3 0_700_M3 4
R_v_M3_1_6 100_600_M3 100_700_M3 4
R_v_M3_2_6 200_600_M3 200_700_M3 4
R_v_M3_3_6 300_600_M3 300_700_M3 4
R_v_M3_4_6 400_600_M3 400_700_M3 4
R_v_M3_5_6 500_600_M3 500_700_M3 4
R_v_M3_6_6 600_600_M3 600_700_M3 4
R_v_M3_7_6 700_600_M3 700_700_M3 4
R_v_M3_8_6 800_600_M3 800_700_M3 4
R_v_M3_9_6 900_600_M3 900_700_M3 4
R_v_M3_0_7 0_700_M3 0_800_M3 4
R_v_M3_1_7 100_700_M3 100_800_M3 4
R_v_M3_2_7 200_700_M3 200_800_M3 4
R_v_M3_3_7 300_700_M3 300_800_M3 4
R_v_M3_4_7 400_700_M3 400_800_M3 4
R_v_M3_5_7 500_700_M3 500_800_M3 4
R_v_M3_6_7 600_700_M3 600_800_M3 4
R_v_M3_7_7 700_700_M3 700_800_M3 4
R_v_M3_8_7 800_700_M3 800_800_M3 4
R_v_M3_9_7 900_700_M3 900_800_M3 4
R_v_M3_0_8 0_800_M3 0_900_M3 4
R_v_M3_1_8 100_800_M3 100_900_M3 4
R_v_M3_2_8 200_800_M3 200_900_M3 4
R_v_M3_3_8 300_800_M3 300_900_M3 4
R_v_M3_4_8 400_800_M3 400_900_M3 4
R_v_M3_5_8 500_800_M3 500_900_M3 4
R_v_M3_6_8 600_800_M3 600_900_M3 4
R_v_M3_7_8 700_800_M3 700_900_M3 4
R_v_M3_8_8 800_800_M3 800_900_M3 4
R_v_M3_9_8 900_800_M3 900_900_M3 4
* Ground capacitors (C=2.0 fF)
C_g_M3_0_0 0_0_M3 0 2e-15
C_g_M3_1_0 100_0_M3 0 2e-15
C_g_M3_2_0 200_0_M3 0 2e-15
C_g_M3_3_0 300_0_M3 0 2e-15
C_g_M3_4_0 400_0_M3 0 2e-15
C_g_M3_5_0 500_0_M3 0 2e-15
C_g_M3_6_0 600_0_M3 0 2e-15
C_g_M3_7_0 700_0_M3 0 2e-15
C_g_M3_8_0 800_0_M3 0 2e-15
C_g_M3_9_0 900_0_M3 0 2e-15
C_g_M3_0_1 0_100_M3 0 2e-15
C_g_M3_1_1 100_100_M3 0 2e-15
C_g_M3_2_1 200_100_M3 0 2e-15
C_g_M3_3_1 300_100_M3 0 2e-15
C_g_M3_4_1 400_100_M3 0 2e-15
C_g_M3_5_1 500_100_M3 0 2e-15
C_g_M3_6_1 600_100_M3 0 2e-15
C_g_M3_7_1 700_100_M3 0 2e-15
C_g_M3_8_1 800_100_M3 0 2e-15
C_g_M3_9_1 900_100_M3 0 2e-15
C_g_M3_0_2 0_200_M3 0 2e-15
C_g_M3_1_2 100_200_M3 0 2e-15
C_g_M3_2_2 200_200_M3 0 2e-15
C_g_M3_3_2 300_200_M3 0 2e-15
C_g_M3_4_2 400_200_M3 0 2e-15
C_g_M3_5_2 500_200_M3 0 2e-15
C_g_M3_6_2 600_200_M3 0 2e-15
C_g_M3_7_2 700_200_M3 0 2e-15
C_g_M3_8_2 800_200_M3 0 2e-15
C_g_M3_9_2 900_200_M3 0 2e-15
C_g_M3_0_3 0_300_M3 0 2e-15
C_g_M3_1_3 100_300_M3 0 2e-15
C_g_M3_2_3 200_300_M3 0 2e-15
C_g_M3_3_3 300_300_M3 0 2e-15
C_g_M3_4_3 400_300_M3 0 2e-15
C_g_M3_5_3 500_300_M3 0 2e-15
C_g_M3_6_3 600_300_M3 0 2e-15
C_g_M3_7_3 700_300_M3 0 2e-15
C_g_M3_8_3 800_300_M3 0 2e-15
C_g_M3_9_3 900_300_M3 0 2e-15
C_g_M3_0_4 0_400_M3 0 2e-15
C_g_M3_1_4 100_400_M3 0 2e-15
C_g_M3_2_4 200_400_M3 0 2e-15
C_g_M3_3_4 300_400_M3 0 2e-15
C_g_M3_4_4 400_400_M3 0 2e-15
C_g_M3_5_4 500_400_M3 0 2e-15
C_g_M3_6_4 600_400_M3 0 2e-15
C_g_M3_7_4 700_400_M3 0 2e-15
C_g_M3_8_4 800_400_M3 0 2e-15
C_g_M3_9_4 900_400_M3 0 2e-15
C_g_M3_0_5 0_500_M3 0 2e-15
C_g_M3_1_5 100_500_M3 0 2e-15
C_g_M3_2_5 200_500_M3 0 2e-15
C_g_M3_3_5 300_500_M3 0 2e-15
C_g_M3_4_5 400_500_M3 0 2e-15
C_g_M3_5_5 500_500_M3 0 2e-15
C_g_M3_6_5 600_500_M3 0 2e-15
C_g_M3_7_5 700_500_M3 0 2e-15
C_g_M3_8_5 800_500_M3 0 2e-15
C_g_M3_9_5 900_500_M3 0 2e-15
C_g_M3_0_6 0_600_M3 0 2e-15
C_g_M3_1_6 100_600_M3 0 2e-15
C_g_M3_2_6 200_600_M3 0 2e-15
C_g_M3_3_6 300_600_M3 0 2e-15
C_g_M3_4_6 400_600_M3 0 2e-15
C_g_M3_5_6 500_600_M3 0 2e-15
C_g_M3_6_6 600_600_M3 0 2e-15
C_g_M3_7_6 700_600_M3 0 2e-15
C_g_M3_8_6 800_600_M3 0 2e-15
C_g_M3_9_6 900_600_M3 0 2e-15
C_g_M3_0_7 0_700_M3 0 2e-15
C_g_M3_1_7 100_700_M3 0 2e-15
C_g_M3_2_7 200_700_M3 0 2e-15
C_g_M3_3_7 300_700_M3 0 2e-15
C_g_M3_4_7 400_700_M3 0 2e-15
C_g_M3_5_7 500_700_M3 0 2e-15
C_g_M3_6_7 600_700_M3 0 2e-15
C_g_M3_7_7 700_700_M3 0 2e-15
C_g_M3_8_7 800_700_M3 0 2e-15
C_g_M3_9_7 900_700_M3 0 2e-15
C_g_M3_0_8 0_800_M3 0 2e-15
C_g_M3_1_8 100_800_M3 0 2e-15
C_g_M3_2_8 200_800_M3 0 2e-15
C_g_M3_3_8 300_800_M3 0 2e-15
C_g_M3_4_8 400_800_M3 0 2e-15
C_g_M3_5_8 500_800_M3 0 2e-15
C_g_M3_6_8 600_800_M3 0 2e-15
C_g_M3_7_8 700_800_M3 0 2e-15
C_g_M3_8_8 800_800_M3 0 2e-15
C_g_M3_9_8 900_800_M3 0 2e-15
C_g_M3_0_9 0_900_M3 0 2e-15
C_g_M3_1_9 100_900_M3 0 2e-15
C_g_M3_2_9 200_900_M3 0 2e-15
C_g_M3_3_9 300_900_M3 0 2e-15
C_g_M3_4_9 400_900_M3 0 2e-15
C_g_M3_5_9 500_900_M3 0 2e-15
C_g_M3_6_9 600_900_M3 0 2e-15
C_g_M3_7_9 700_900_M3 0 2e-15
C_g_M3_8_9 800_900_M3 0 2e-15
C_g_M3_9_9 900_900_M3 0 2e-15
* Coupling capacitors (C=1.0 fF)
C_coup_M3_0_0 0_0_M3 100_0_M3 1e-15
C_coup_M3_2_0 200_0_M3 300_0_M3 1e-15
C_coup_M3_4_0 400_0_M3 500_0_M3 1e-15
C_coup_M3_6_0 600_0_M3 700_0_M3 1e-15
C_coup_M3_8_0 800_0_M3 900_0_M3 1e-15
C_coup_M3_0_1 0_100_M3 100_100_M3 1e-15
C_coup_M3_2_1 200_100_M3 300_100_M3 1e-15
C_coup_M3_4_1 400_100_M3 500_100_M3 1e-15
C_coup_M3_6_1 600_100_M3 700_100_M3 1e-15
C_coup_M3_8_1 800_100_M3 900_100_M3 1e-15
C_coup_M3_0_2 0_200_M3 100_200_M3 1e-15
C_coup_M3_2_2 200_200_M3 300_200_M3 1e-15
C_coup_M3_4_2 400_200_M3 500_200_M3 1e-15
C_coup_M3_6_2 600_200_M3 700_200_M3 1e-15
C_coup_M3_8_2 800_200_M3 900_200_M3 1e-15
C_coup_M3_0_3 0_300_M3 100_300_M3 1e-15
C_coup_M3_2_3 200_300_M3 300_300_M3 1e-15
C_coup_M3_4_3 400_300_M3 500_300_M3 1e-15
C_coup_M3_6_3 600_300_M3 700_300_M3 1e-15
C_coup_M3_8_3 800_300_M3 900_300_M3 1e-15
C_coup_M3_0_4 0_400_M3 100_400_M3 1e-15
C_coup_M3_2_4 200_400_M3 300_400_M3 1e-15
C_coup_M3_4_4 400_400_M3 500_400_M3 1e-15
C_coup_M3_6_4 600_400_M3 700_400_M3 1e-15
C_coup_M3_8_4 800_400_M3 900_400_M3 1e-15
C_coup_M3_0_5 0_500_M3 100_500_M3 1e-15
C_coup_M3_2_5 200_500_M3 300_500_M3 1e-15
C_coup_M3_4_5 400_500_M3 500_500_M3 1e-15
C_coup_M3_6_5 600_500_M3 700_500_M3 1e-15
C_coup_M3_8_5 800_500_M3 900_500_M3 1e-15
C_coup_M3_0_6 0_600_M3 100_600_M3 1e-15
C_coup_M3_2_6 200_600_M3 300_600_M3 1e-15
C_coup_M3_4_6 400_600_M3 500_600_M3 1e-15
C_coup_M3_6_6 600_600_M3 700_600_M3 1e-15
C_coup_M3_8_6 800_600_M3 900_600_M3 1e-15
C_coup_M3_0_7 0_700_M3 100_700_M3 1e-15
C_coup_M3_2_7 200_700_M3 300_700_M3 1e-15
C_coup_M3_4_7 400_700_M3 500_700_M3 1e-15
C_coup_M3_6_7 600_700_M3 700_700_M3 1e-15
C_coup_M3_8_7 800_700_M3 900_700_M3 1e-15
C_coup_M3_0_8 0_800_M3 100_800_M3 1e-15
C_coup_M3_2_8 200_800_M3 300_800_M3 1e-15
C_coup_M3_4_8 400_800_M3 500_800_M3 1e-15
C_coup_M3_6_8 600_800_M3 700_800_M3 1e-15
C_coup_M3_8_8 800_800_M3 900_800_M3 1e-15
C_coup_M3_0_9 0_900_M3 100_900_M3 1e-15
C_coup_M3_2_9 200_900_M3 300_900_M3 1e-15
C_coup_M3_4_9 400_900_M3 500_900_M3 1e-15
C_coup_M3_6_9 600_900_M3 700_900_M3 1e-15
C_coup_M3_8_9 800_900_M3 900_900_M3 1e-15

* ========== Via connections ==========
* Vias M1 to M2 (R=0.5 Ohm)
R_via_M1_M2_0_0 0_0_M1 0_0_M2 0.5
R_via_M1_M2_2_0 200_0_M1 200_0_M2 0.5
R_via_M1_M2_4_0 400_0_M1 400_0_M2 0.5
R_via_M1_M2_6_0 600_0_M1 600_0_M2 0.5
R_via_M1_M2_8_0 800_0_M1 800_0_M2 0.5
R_via_M1_M2_0_2 0_200_M1 0_200_M2 0.5
R_via_M1_M2_2_2 200_200_M1 200_200_M2 0.5
R_via_M1_M2_4_2 400_200_M1 400_200_M2 0.5
R_via_M1_M2_6_2 600_200_M1 600_200_M2 0.5
R_via_M1_M2_8_2 800_200_M1 800_200_M2 0.5
R_via_M1_M2_0_4 0_400_M1 0_400_M2 0.5
R_via_M1_M2_2_4 200_400_M1 200_400_M2 0.5
R_via_M1_M2_4_4 400_400_M1 400_400_M2 0.5
R_via_M1_M2_6_4 600_400_M1 600_400_M2 0.5
R_via_M1_M2_8_4 800_400_M1 800_400_M2 0.5
R_via_M1_M2_0_6 0_600_M1 0_600_M2 0.5
R_via_M1_M2_2_6 200_600_M1 200_600_M2 0.5
R_via_M1_M2_4_6 400_600_M1 400_600_M2 0.5
R_via_M1_M2_6_6 600_600_M1 600_600_M2 0.5
R_via_M1_M2_8_6 800_600_M1 800_600_M2 0.5
R_via_M1_M2_0_8 0_800_M1 0_800_M2 0.5
R_via_M1_M2_2_8 200_800_M1 200_800_M2 0.5
R_via_M1_M2_4_8 400_800_M1 400_800_M2 0.5
R_via_M1_M2_6_8 600_800_M1 600_800_M2 0.5
R_via_M1_M2_8_8 800_800_M1 800_800_M2 0.5
* Vias M2 to M3 (R=0.3 Ohm)
R_via_M2_M3_0_0 0_0_M2 0_0_M3 0.3
R_via_M2_M3_2_0 200_0_M2 200_0_M3 0.3
R_via_M2_M3_4_0 400_0_M2 400_0_M3 0.3
R_via_M2_M3_6_0 600_0_M2 600_0_M3 0.3
R_via_M2_M3_8_0 800_0_M2 800_0_M3 0.3
R_via_M2_M3_0_2 0_200_M2 0_200_M3 0.3
R_via_M2_M3_2_2 200_200_M2 200_200_M3 0.3
R_via_M2_M3_4_2 400_200_M2 400_200_M3 0.3
R_via_M2_M3_6_2 600_200_M2 600_200_M3 0.3
R_via_M2_M3_8_2 800_200_M2 800_200_M3 0.3
R_via_M2_M3_0_4 0_400_M2 0_400_M3 0.3
R_via_M2_M3_2_4 200_400_M2 200_400_M3 0.3
R_via_M2_M3_4_4 400_400_M2 400_400_M3 0.3
R_via_M2_M3_6_4 600_400_M2 600_400_M3 0.3
R_via_M2_M3_8_4 800_400_M2 800_400_M3 0.3
R_via_M2_M3_0_6 0_600_M2 0_600_M3 0.3
R_via_M2_M3_2_6 200_600_M2 200_600_M3 0.3
R_via_M2_M3_4_6 400_600_M2 400_600_M3 0.3
R_via_M2_M3_6_6 600_600_M2 600_600_M3 0.3
R_via_M2_M3_8_6 800_600_M2 800_600_M3 0.3
R_via_M2_M3_0_8 0_800_M2 0_800_M3 0.3
R_via_M2_M3_2_8 200_800_M2 200_800_M3 0.3
R_via_M2_M3_4_8 400_800_M2 400_800_M3 0.3
R_via_M2_M3_6_8 600_800_M2 600_800_M3 0.3
R_via_M2_M3_8_8 800_800_M2 800_800_M3 0.3

* ========== Decoupling capacitors ==========
C_decap_1_1 100_100_M1 0 2e-13
C_decap_4_1 400_100_M1 0 5e-14
C_decap_7_1 700_100_M1 0 2e-13
C_decap_1_4 100_400_M1 0 5e-14
C_decap_4_4 400_400_M1 0 2e-13
C_decap_7_4 700_400_M1 0 5e-14
C_decap_1_7 100_700_M1 0 2e-13
C_decap_4_7 400_700_M1 0 5e-14
C_decap_7_7 700_700_M1 0 2e-13
* (9 decaps placed)

* ========== Boundary connections ==========
* Right boundary to tile_1_0
R_bnd_r_M1_0 *900_0_M1 *1000_0_M1 8
R_bnd_r_M2_0 *900_0_M2 *1000_0_M2 5
R_bnd_r_M3_0 *900_0_M3 *1000_0_M3 3
R_bnd_r_M1_1 *900_100_M1 *1000_100_M1 8
R_bnd_r_M2_1 *900_100_M2 *1000_100_M2 5
R_bnd_r_M3_1 *900_100_M3 *1000_100_M3 3
R_bnd_r_M1_2 *900_200_M1 *1000_200_M1 8
R_bnd_r_M2_2 *900_200_M2 *1000_200_M2 5
R_bnd_r_M3_2 *900_200_M3 *1000_200_M3 3
R_bnd_r_M1_3 *900_300_M1 *1000_300_M1 8
R_bnd_r_M2_3 *900_300_M2 *1000_300_M2 5
R_bnd_r_M3_3 *900_300_M3 *1000_300_M3 3
R_bnd_r_M1_4 *900_400_M1 *1000_400_M1 8
R_bnd_r_M2_4 *900_400_M2 *1000_400_M2 5
R_bnd_r_M3_4 *900_400_M3 *1000_400_M3 3
R_bnd_r_M1_5 *900_500_M1 *1000_500_M1 8
R_bnd_r_M2_5 *900_500_M2 *1000_500_M2 5
R_bnd_r_M3_5 *900_500_M3 *1000_500_M3 3
R_bnd_r_M1_6 *900_600_M1 *1000_600_M1 8
R_bnd_r_M2_6 *900_600_M2 *1000_600_M2 5
R_bnd_r_M3_6 *900_600_M3 *1000_600_M3 3
R_bnd_r_M1_7 *900_700_M1 *1000_700_M1 8
R_bnd_r_M2_7 *900_700_M2 *1000_700_M2 5
R_bnd_r_M3_7 *900_700_M3 *1000_700_M3 3
R_bnd_r_M1_8 *900_800_M1 *1000_800_M1 8
R_bnd_r_M2_8 *900_800_M2 *1000_800_M2 5
R_bnd_r_M3_8 *900_800_M3 *1000_800_M3 3
R_bnd_r_M1_9 *900_900_M1 *1000_900_M1 8
R_bnd_r_M2_9 *900_900_M2 *1000_900_M2 5
R_bnd_r_M3_9 *900_900_M3 *1000_900_M3 3
* Top boundary to tile_0_1
R_bnd_t_M1_0 *0_900_M1 *0_1000_M1 10
R_bnd_t_M2_0 *0_900_M2 *0_1000_M2 6
R_bnd_t_M3_0 *0_900_M3 *0_1000_M3 4
R_bnd_t_M1_1 *100_900_M1 *100_1000_M1 10
R_bnd_t_M2_1 *100_900_M2 *100_1000_M2 6
R_bnd_t_M3_1 *100_900_M3 *100_1000_M3 4
R_bnd_t_M1_2 *200_900_M1 *200_1000_M1 10
R_bnd_t_M2_2 *200_900_M2 *200_1000_M2 6
R_bnd_t_M3_2 *200_900_M3 *200_1000_M3 4
R_bnd_t_M1_3 *300_900_M1 *300_1000_M1 10
R_bnd_t_M2_3 *300_900_M2 *300_1000_M2 6
R_bnd_t_M3_3 *300_900_M3 *300_1000_M3 4
R_bnd_t_M1_4 *400_900_M1 *400_1000_M1 10
R_bnd_t_M2_4 *400_900_M2 *400_1000_M2 6
R_bnd_t_M3_4 *400_900_M3 *400_1000_M3 4
R_bnd_t_M1_5 *500_900_M1 *500_1000_M1 10
R_bnd_t_M2_5 *500_900_M2 *500_1000_M2 6
R_bnd_t_M3_5 *500_900_M3 *500_1000_M3 4
R_bnd_t_M1_6 *600_900_M1 *600_1000_M1 10
R_bnd_t_M2_6 *600_900_M2 *600_1000_M2 6
R_bnd_t_M3_6 *600_900_M3 *600_1000_M3 4
R_bnd_t_M1_7 *700_900_M1 *700_1000_M1 10
R_bnd_t_M2_7 *700_900_M2 *700_1000_M2 6
R_bnd_t_M3_7 *700_900_M3 *700_1000_M3 4
R_bnd_t_M1_8 *800_900_M1 *800_1000_M1 10
R_bnd_t_M2_8 *800_900_M2 *800_1000_M2 6
R_bnd_t_M3_8 *800_900_M3 *800_1000_M3 4
R_bnd_t_M1_9 *900_900_M1 *900_1000_M1 10
R_bnd_t_M2_9 *900_900_M2 *900_1000_M2 6
R_bnd_t_M3_9 *900_900_M3 *900_1000_M3 4

* Tile 0_0 summary: 650 R, 459 C
