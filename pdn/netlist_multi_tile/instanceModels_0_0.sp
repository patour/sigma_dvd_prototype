* Instance models for tile 0_0
* Current sources with static and dynamic currents
* Some nodes have multiple current sources (overlapping)

I_0_0_0_3 0_300_M1 0 1.3281e-03
I_0_0_8_6 800_600_M1 0 8.8058e-04 static_value=5.7111e-04
I_0_0_7_5 700_500_M1 0 0 pulse(4.3085e-04, 2.1547e-03, 1.4091e-09, 1.1833e-10, 1.9116e-10, 2.8682e-09, 8.5585e-09)
I_0_0_1_7 100_700_M1 0 0 pwl(0.0000e+00 2.1662e-03 1.7603e-09 1.1335e-03 4.4285e-09 4.0664e-04 6.1390e-09 1.6754e-03 8.5427e-09 1.7089e-03) pwl_period=1.1320e-08
I_0_0_9_4 900_400_M1 0 3.6024e-04 pulse(0, 7.4481e-04, 0, 0.2n, 0.2n, 4.3868e-09, 1.2699e-08)
I_0_0_2_7 200_700_M1 0 3.7762e-04 pwl(0 0 2n 8.4408e-04 5n 1.2196e-03 8n 4.6214e-04) pwl_period=10n
I_0_0_2_9 200_900_M1 0 1.6525e-03
I_0_0_5_4 500_400_M1 0 3.3916e-04 static_value=6.9308e-04
I_0_0_8_1 800_100_M1 0 0 pulse(4.0252e-04, 1.8023e-03, 1.3238e-10, 4.6525e-10, 3.2687e-10, 4.1537e-09, 9.4884e-09)
I_0_0_8_6_2 800_600_M1 0 0 pwl(0.0000e+00 9.8908e-04 2.8291e-09 1.1471e-03 4.3589e-09 6.1657e-04 6.4816e-09 6.5685e-04 8.6508e-09 2.2446e-03 1.0450e-08 5.4830e-04 1.3445e-08 1.2738e-03) pwl_period=1.5674e-08
I_0_0_1_1 100_100_M1 0 2.3289e-04 pulse(0, 1.1274e-03, 0, 0.2n, 0.2n, 5.3762e-09, 1.4222e-08)
I_0_0_6_9 600_900_M1 0 1.1906e-04 pwl(0 0 2n 6.9081e-04 5n 1.9961e-03 8n 5.6456e-04) pwl_period=10n
I_0_0_0_4 0_400_M1 0 1.9566e-03
I_0_0_1_3 100_300_M1 0 9.0255e-04 static_value=2.0689e-04
I_0_0_1_4 100_400_M1 0 0 pulse(3.6036e-04, 2.3634e-03, 1.0739e-09, 2.0673e-10, 3.5638e-10, 2.3347e-09, 1.1043e-08)
I_0_0_9_4_2 900_400_M1 0 0 pwl(0.0000e+00 8.1133e-06 2.4442e-09 1.7992e-03 5.3880e-09 1.9049e-03 7.4033e-09 2.6603e-04 9.6539e-09 2.1042e-03 1.1669e-08 4.9728e-04 1.3417e-08 4.0387e-04) pwl_period=1.8247e-08
I_0_0_1_1_2 100_100_M1 0 4.7555e-04 pulse(0, 1.0989e-03, 0, 0.2n, 0.2n, 4.4658e-09, 1.1119e-08)
I_0_0_2_8 200_800_M1 0 2.0889e-04 pwl(0 0 2n 9.9266e-04 5n 1.8068e-03 8n 4.1973e-04) pwl_period=10n
I_0_0_3_5 300_500_M1 0 8.6131e-04
I_0_0_1_3_2 100_300_M1 0 6.9715e-04 static_value=2.4725e-04
I_0_0_6_9_2 600_900_M1 0 0 pulse(3.6595e-04, 2.6320e-03, 1.9560e-09, 3.1308e-10, 1.5030e-10, 3.9793e-09, 1.4628e-08)
I_0_0_5_4_2 500_400_M1 0 0 pwl(0.0000e+00 6.6264e-04 2.7449e-09 1.0578e-03 4.1685e-09 1.3482e-03 6.6283e-09 5.0288e-04 8.2518e-09 2.4879e-03) pwl_period=1.1990e-08
I_0_0_9_4_3 900_400_M1 0 3.5527e-04 pulse(0, 6.2100e-04, 0, 0.2n, 0.2n, 3.6741e-09, 1.3381e-08)
I_0_0_3_1 300_100_M1 0 2.7649e-04 pwl(0 0 2n 6.1506e-04 5n 1.2202e-03 8n 3.3550e-04) pwl_period=10n
I_0_0_8_1_2 800_100_M1 0 1.4467e-03

* Tile 0_0 summary:
*   Total current sources: 25
*   With static current: 17
*   With waveforms: 16
*   Overlapping nodes: 8
