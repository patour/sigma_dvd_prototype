* Tile 2_0 netlist
* Multi-layer routing with R, C elements
* Includes ground caps, coupling caps, and decaps

* ========== Layer M1 ==========
* Horizontal resistors (R=8 Ohm)
R_h_M1_0_0 2000_0_M1 2100_0_M1 8
R_h_M1_1_0 2100_0_M1 2200_0_M1 8
R_h_M1_2_0 2200_0_M1 2300_0_M1 8
R_h_M1_3_0 2300_0_M1 2400_0_M1 8
R_h_M1_4_0 2400_0_M1 2500_0_M1 8
R_h_M1_5_0 2500_0_M1 2600_0_M1 8
R_h_M1_6_0 2600_0_M1 2700_0_M1 8
R_h_M1_7_0 2700_0_M1 2800_0_M1 8
R_h_M1_8_0 2800_0_M1 2900_0_M1 8
R_h_M1_0_1 2000_100_M1 2100_100_M1 8
R_h_M1_1_1 2100_100_M1 2200_100_M1 8
R_h_M1_2_1 2200_100_M1 2300_100_M1 8
R_h_M1_3_1 2300_100_M1 2400_100_M1 8
R_h_M1_4_1 2400_100_M1 2500_100_M1 8
R_h_M1_5_1 2500_100_M1 2600_100_M1 8
R_h_M1_6_1 2600_100_M1 2700_100_M1 8
R_h_M1_7_1 2700_100_M1 2800_100_M1 8
R_h_M1_8_1 2800_100_M1 2900_100_M1 8
R_h_M1_0_2 2000_200_M1 2100_200_M1 8
R_h_M1_1_2 2100_200_M1 2200_200_M1 8
R_h_M1_2_2 2200_200_M1 2300_200_M1 8
R_h_M1_3_2 2300_200_M1 2400_200_M1 8
R_h_M1_4_2 2400_200_M1 2500_200_M1 8
R_h_M1_5_2 2500_200_M1 2600_200_M1 8
R_h_M1_6_2 2600_200_M1 2700_200_M1 8
R_h_M1_7_2 2700_200_M1 2800_200_M1 8
R_h_M1_8_2 2800_200_M1 2900_200_M1 8
R_h_M1_0_3 2000_300_M1 2100_300_M1 8
R_h_M1_1_3 2100_300_M1 2200_300_M1 8
R_h_M1_2_3 2200_300_M1 2300_300_M1 8
R_h_M1_3_3 2300_300_M1 2400_300_M1 8
R_h_M1_4_3 2400_300_M1 2500_300_M1 8
R_h_M1_5_3 2500_300_M1 2600_300_M1 8
R_h_M1_6_3 2600_300_M1 2700_300_M1 8
R_h_M1_7_3 2700_300_M1 2800_300_M1 8
R_h_M1_8_3 2800_300_M1 2900_300_M1 8
R_h_M1_0_4 2000_400_M1 2100_400_M1 8
R_h_M1_1_4 2100_400_M1 2200_400_M1 8
R_h_M1_2_4 2200_400_M1 2300_400_M1 8
R_h_M1_3_4 2300_400_M1 2400_400_M1 8
R_h_M1_4_4 2400_400_M1 2500_400_M1 8
R_h_M1_5_4 2500_400_M1 2600_400_M1 8
R_h_M1_6_4 2600_400_M1 2700_400_M1 8
R_h_M1_7_4 2700_400_M1 2800_400_M1 8
R_h_M1_8_4 2800_400_M1 2900_400_M1 8
R_h_M1_0_5 2000_500_M1 2100_500_M1 8
R_h_M1_1_5 2100_500_M1 2200_500_M1 8
R_h_M1_2_5 2200_500_M1 2300_500_M1 8
R_h_M1_3_5 2300_500_M1 2400_500_M1 8
R_h_M1_4_5 2400_500_M1 2500_500_M1 8
R_h_M1_5_5 2500_500_M1 2600_500_M1 8
R_h_M1_6_5 2600_500_M1 2700_500_M1 8
R_h_M1_7_5 2700_500_M1 2800_500_M1 8
R_h_M1_8_5 2800_500_M1 2900_500_M1 8
R_h_M1_0_6 2000_600_M1 2100_600_M1 8
R_h_M1_1_6 2100_600_M1 2200_600_M1 8
R_h_M1_2_6 2200_600_M1 2300_600_M1 8
R_h_M1_3_6 2300_600_M1 2400_600_M1 8
R_h_M1_4_6 2400_600_M1 2500_600_M1 8
R_h_M1_5_6 2500_600_M1 2600_600_M1 8
R_h_M1_6_6 2600_600_M1 2700_600_M1 8
R_h_M1_7_6 2700_600_M1 2800_600_M1 8
R_h_M1_8_6 2800_600_M1 2900_600_M1 8
R_h_M1_0_7 2000_700_M1 2100_700_M1 8
R_h_M1_1_7 2100_700_M1 2200_700_M1 8
R_h_M1_2_7 2200_700_M1 2300_700_M1 8
R_h_M1_3_7 2300_700_M1 2400_700_M1 8
R_h_M1_4_7 2400_700_M1 2500_700_M1 8
R_h_M1_5_7 2500_700_M1 2600_700_M1 8
R_h_M1_6_7 2600_700_M1 2700_700_M1 8
R_h_M1_7_7 2700_700_M1 2800_700_M1 8
R_h_M1_8_7 2800_700_M1 2900_700_M1 8
R_h_M1_0_8 2000_800_M1 2100_800_M1 8
R_h_M1_1_8 2100_800_M1 2200_800_M1 8
R_h_M1_2_8 2200_800_M1 2300_800_M1 8
R_h_M1_3_8 2300_800_M1 2400_800_M1 8
R_h_M1_4_8 2400_800_M1 2500_800_M1 8
R_h_M1_5_8 2500_800_M1 2600_800_M1 8
R_h_M1_6_8 2600_800_M1 2700_800_M1 8
R_h_M1_7_8 2700_800_M1 2800_800_M1 8
R_h_M1_8_8 2800_800_M1 2900_800_M1 8
R_h_M1_0_9 2000_900_M1 2100_900_M1 8
R_h_M1_1_9 2100_900_M1 2200_900_M1 8
R_h_M1_2_9 2200_900_M1 2300_900_M1 8
R_h_M1_3_9 2300_900_M1 2400_900_M1 8
R_h_M1_4_9 2400_900_M1 2500_900_M1 8
R_h_M1_5_9 2500_900_M1 2600_900_M1 8
R_h_M1_6_9 2600_900_M1 2700_900_M1 8
R_h_M1_7_9 2700_900_M1 2800_900_M1 8
R_h_M1_8_9 2800_900_M1 2900_900_M1 8
* Vertical resistors (R=10 Ohm)
R_v_M1_0_0 2000_0_M1 2000_100_M1 10
R_v_M1_1_0 2100_0_M1 2100_100_M1 10
R_v_M1_2_0 2200_0_M1 2200_100_M1 10
R_v_M1_3_0 2300_0_M1 2300_100_M1 10
R_v_M1_4_0 2400_0_M1 2400_100_M1 10
R_v_M1_5_0 2500_0_M1 2500_100_M1 10
R_v_M1_6_0 2600_0_M1 2600_100_M1 10
R_v_M1_7_0 2700_0_M1 2700_100_M1 10
R_v_M1_8_0 2800_0_M1 2800_100_M1 10
R_v_M1_9_0 2900_0_M1 2900_100_M1 10
R_v_M1_0_1 2000_100_M1 2000_200_M1 10
R_v_M1_1_1 2100_100_M1 2100_200_M1 10
R_v_M1_2_1 2200_100_M1 2200_200_M1 10
R_v_M1_3_1 2300_100_M1 2300_200_M1 10
R_v_M1_4_1 2400_100_M1 2400_200_M1 10
R_v_M1_5_1 2500_100_M1 2500_200_M1 10
R_v_M1_6_1 2600_100_M1 2600_200_M1 10
R_v_M1_7_1 2700_100_M1 2700_200_M1 10
R_v_M1_8_1 2800_100_M1 2800_200_M1 10
R_v_M1_9_1 2900_100_M1 2900_200_M1 10
R_v_M1_0_2 2000_200_M1 2000_300_M1 10
R_v_M1_1_2 2100_200_M1 2100_300_M1 10
R_v_M1_2_2 2200_200_M1 2200_300_M1 10
R_v_M1_3_2 2300_200_M1 2300_300_M1 10
R_v_M1_4_2 2400_200_M1 2400_300_M1 10
R_v_M1_5_2 2500_200_M1 2500_300_M1 10
R_v_M1_6_2 2600_200_M1 2600_300_M1 10
R_v_M1_7_2 2700_200_M1 2700_300_M1 10
R_v_M1_8_2 2800_200_M1 2800_300_M1 10
R_v_M1_9_2 2900_200_M1 2900_300_M1 10
R_v_M1_0_3 2000_300_M1 2000_400_M1 10
R_v_M1_1_3 2100_300_M1 2100_400_M1 10
R_v_M1_2_3 2200_300_M1 2200_400_M1 10
R_v_M1_3_3 2300_300_M1 2300_400_M1 10
R_v_M1_4_3 2400_300_M1 2400_400_M1 10
R_v_M1_5_3 2500_300_M1 2500_400_M1 10
R_v_M1_6_3 2600_300_M1 2600_400_M1 10
R_v_M1_7_3 2700_300_M1 2700_400_M1 10
R_v_M1_8_3 2800_300_M1 2800_400_M1 10
R_v_M1_9_3 2900_300_M1 2900_400_M1 10
R_v_M1_0_4 2000_400_M1 2000_500_M1 10
R_v_M1_1_4 2100_400_M1 2100_500_M1 10
R_v_M1_2_4 2200_400_M1 2200_500_M1 10
R_v_M1_3_4 2300_400_M1 2300_500_M1 10
R_v_M1_4_4 2400_400_M1 2400_500_M1 10
R_v_M1_5_4 2500_400_M1 2500_500_M1 10
R_v_M1_6_4 2600_400_M1 2600_500_M1 10
R_v_M1_7_4 2700_400_M1 2700_500_M1 10
R_v_M1_8_4 2800_400_M1 2800_500_M1 10
R_v_M1_9_4 2900_400_M1 2900_500_M1 10
R_v_M1_0_5 2000_500_M1 2000_600_M1 10
R_v_M1_1_5 2100_500_M1 2100_600_M1 10
R_v_M1_2_5 2200_500_M1 2200_600_M1 10
R_v_M1_3_5 2300_500_M1 2300_600_M1 10
R_v_M1_4_5 2400_500_M1 2400_600_M1 10
R_v_M1_5_5 2500_500_M1 2500_600_M1 10
R_v_M1_6_5 2600_500_M1 2600_600_M1 10
R_v_M1_7_5 2700_500_M1 2700_600_M1 10
R_v_M1_8_5 2800_500_M1 2800_600_M1 10
R_v_M1_9_5 2900_500_M1 2900_600_M1 10
R_v_M1_0_6 2000_600_M1 2000_700_M1 10
R_v_M1_1_6 2100_600_M1 2100_700_M1 10
R_v_M1_2_6 2200_600_M1 2200_700_M1 10
R_v_M1_3_6 2300_600_M1 2300_700_M1 10
R_v_M1_4_6 2400_600_M1 2400_700_M1 10
R_v_M1_5_6 2500_600_M1 2500_700_M1 10
R_v_M1_6_6 2600_600_M1 2600_700_M1 10
R_v_M1_7_6 2700_600_M1 2700_700_M1 10
R_v_M1_8_6 2800_600_M1 2800_700_M1 10
R_v_M1_9_6 2900_600_M1 2900_700_M1 10
R_v_M1_0_7 2000_700_M1 2000_800_M1 10
R_v_M1_1_7 2100_700_M1 2100_800_M1 10
R_v_M1_2_7 2200_700_M1 2200_800_M1 10
R_v_M1_3_7 2300_700_M1 2300_800_M1 10
R_v_M1_4_7 2400_700_M1 2400_800_M1 10
R_v_M1_5_7 2500_700_M1 2500_800_M1 10
R_v_M1_6_7 2600_700_M1 2600_800_M1 10
R_v_M1_7_7 2700_700_M1 2700_800_M1 10
R_v_M1_8_7 2800_700_M1 2800_800_M1 10
R_v_M1_9_7 2900_700_M1 2900_800_M1 10
R_v_M1_0_8 2000_800_M1 2000_900_M1 10
R_v_M1_1_8 2100_800_M1 2100_900_M1 10
R_v_M1_2_8 2200_800_M1 2200_900_M1 10
R_v_M1_3_8 2300_800_M1 2300_900_M1 10
R_v_M1_4_8 2400_800_M1 2400_900_M1 10
R_v_M1_5_8 2500_800_M1 2500_900_M1 10
R_v_M1_6_8 2600_800_M1 2600_900_M1 10
R_v_M1_7_8 2700_800_M1 2700_900_M1 10
R_v_M1_8_8 2800_800_M1 2800_900_M1 10
R_v_M1_9_8 2900_800_M1 2900_900_M1 10
* Ground capacitors (C=5.0 fF)
C_g_M1_0_0 2000_0_M1 0 5e-15
C_g_M1_1_0 2100_0_M1 0 5e-15
C_g_M1_2_0 2200_0_M1 0 5e-15
C_g_M1_3_0 2300_0_M1 0 5e-15
C_g_M1_4_0 2400_0_M1 0 5e-15
C_g_M1_5_0 2500_0_M1 0 5e-15
C_g_M1_6_0 2600_0_M1 0 5e-15
C_g_M1_7_0 2700_0_M1 0 5e-15
C_g_M1_8_0 2800_0_M1 0 5e-15
C_g_M1_9_0 2900_0_M1 0 5e-15
C_g_M1_0_1 2000_100_M1 0 5e-15
C_g_M1_1_1 2100_100_M1 0 5e-15
C_g_M1_2_1 2200_100_M1 0 5e-15
C_g_M1_3_1 2300_100_M1 0 5e-15
C_g_M1_4_1 2400_100_M1 0 5e-15
C_g_M1_5_1 2500_100_M1 0 5e-15
C_g_M1_6_1 2600_100_M1 0 5e-15
C_g_M1_7_1 2700_100_M1 0 5e-15
C_g_M1_8_1 2800_100_M1 0 5e-15
C_g_M1_9_1 2900_100_M1 0 5e-15
C_g_M1_0_2 2000_200_M1 0 5e-15
C_g_M1_1_2 2100_200_M1 0 5e-15
C_g_M1_2_2 2200_200_M1 0 5e-15
C_g_M1_3_2 2300_200_M1 0 5e-15
C_g_M1_4_2 2400_200_M1 0 5e-15
C_g_M1_5_2 2500_200_M1 0 5e-15
C_g_M1_6_2 2600_200_M1 0 5e-15
C_g_M1_7_2 2700_200_M1 0 5e-15
C_g_M1_8_2 2800_200_M1 0 5e-15
C_g_M1_9_2 2900_200_M1 0 5e-15
C_g_M1_0_3 2000_300_M1 0 5e-15
C_g_M1_1_3 2100_300_M1 0 5e-15
C_g_M1_2_3 2200_300_M1 0 5e-15
C_g_M1_3_3 2300_300_M1 0 5e-15
C_g_M1_4_3 2400_300_M1 0 5e-15
C_g_M1_5_3 2500_300_M1 0 5e-15
C_g_M1_6_3 2600_300_M1 0 5e-15
C_g_M1_7_3 2700_300_M1 0 5e-15
C_g_M1_8_3 2800_300_M1 0 5e-15
C_g_M1_9_3 2900_300_M1 0 5e-15
C_g_M1_0_4 2000_400_M1 0 5e-15
C_g_M1_1_4 2100_400_M1 0 5e-15
C_g_M1_2_4 2200_400_M1 0 5e-15
C_g_M1_3_4 2300_400_M1 0 5e-15
C_g_M1_4_4 2400_400_M1 0 5e-15
C_g_M1_5_4 2500_400_M1 0 5e-15
C_g_M1_6_4 2600_400_M1 0 5e-15
C_g_M1_7_4 2700_400_M1 0 5e-15
C_g_M1_8_4 2800_400_M1 0 5e-15
C_g_M1_9_4 2900_400_M1 0 5e-15
C_g_M1_0_5 2000_500_M1 0 5e-15
C_g_M1_1_5 2100_500_M1 0 5e-15
C_g_M1_2_5 2200_500_M1 0 5e-15
C_g_M1_3_5 2300_500_M1 0 5e-15
C_g_M1_4_5 2400_500_M1 0 5e-15
C_g_M1_5_5 2500_500_M1 0 5e-15
C_g_M1_6_5 2600_500_M1 0 5e-15
C_g_M1_7_5 2700_500_M1 0 5e-15
C_g_M1_8_5 2800_500_M1 0 5e-15
C_g_M1_9_5 2900_500_M1 0 5e-15
C_g_M1_0_6 2000_600_M1 0 5e-15
C_g_M1_1_6 2100_600_M1 0 5e-15
C_g_M1_2_6 2200_600_M1 0 5e-15
C_g_M1_3_6 2300_600_M1 0 5e-15
C_g_M1_4_6 2400_600_M1 0 5e-15
C_g_M1_5_6 2500_600_M1 0 5e-15
C_g_M1_6_6 2600_600_M1 0 5e-15
C_g_M1_7_6 2700_600_M1 0 5e-15
C_g_M1_8_6 2800_600_M1 0 5e-15
C_g_M1_9_6 2900_600_M1 0 5e-15
C_g_M1_0_7 2000_700_M1 0 5e-15
C_g_M1_1_7 2100_700_M1 0 5e-15
C_g_M1_2_7 2200_700_M1 0 5e-15
C_g_M1_3_7 2300_700_M1 0 5e-15
C_g_M1_4_7 2400_700_M1 0 5e-15
C_g_M1_5_7 2500_700_M1 0 5e-15
C_g_M1_6_7 2600_700_M1 0 5e-15
C_g_M1_7_7 2700_700_M1 0 5e-15
C_g_M1_8_7 2800_700_M1 0 5e-15
C_g_M1_9_7 2900_700_M1 0 5e-15
C_g_M1_0_8 2000_800_M1 0 5e-15
C_g_M1_1_8 2100_800_M1 0 5e-15
C_g_M1_2_8 2200_800_M1 0 5e-15
C_g_M1_3_8 2300_800_M1 0 5e-15
C_g_M1_4_8 2400_800_M1 0 5e-15
C_g_M1_5_8 2500_800_M1 0 5e-15
C_g_M1_6_8 2600_800_M1 0 5e-15
C_g_M1_7_8 2700_800_M1 0 5e-15
C_g_M1_8_8 2800_800_M1 0 5e-15
C_g_M1_9_8 2900_800_M1 0 5e-15
C_g_M1_0_9 2000_900_M1 0 5e-15
C_g_M1_1_9 2100_900_M1 0 5e-15
C_g_M1_2_9 2200_900_M1 0 5e-15
C_g_M1_3_9 2300_900_M1 0 5e-15
C_g_M1_4_9 2400_900_M1 0 5e-15
C_g_M1_5_9 2500_900_M1 0 5e-15
C_g_M1_6_9 2600_900_M1 0 5e-15
C_g_M1_7_9 2700_900_M1 0 5e-15
C_g_M1_8_9 2800_900_M1 0 5e-15
C_g_M1_9_9 2900_900_M1 0 5e-15
* Coupling capacitors (C=1.0 fF)
C_coup_M1_0_0 2000_0_M1 2100_0_M1 1e-15
C_coup_M1_2_0 2200_0_M1 2300_0_M1 1e-15
C_coup_M1_4_0 2400_0_M1 2500_0_M1 1e-15
C_coup_M1_6_0 2600_0_M1 2700_0_M1 1e-15
C_coup_M1_8_0 2800_0_M1 2900_0_M1 1e-15
C_coup_M1_0_1 2000_100_M1 2100_100_M1 1e-15
C_coup_M1_2_1 2200_100_M1 2300_100_M1 1e-15
C_coup_M1_4_1 2400_100_M1 2500_100_M1 1e-15
C_coup_M1_6_1 2600_100_M1 2700_100_M1 1e-15
C_coup_M1_8_1 2800_100_M1 2900_100_M1 1e-15
C_coup_M1_0_2 2000_200_M1 2100_200_M1 1e-15
C_coup_M1_2_2 2200_200_M1 2300_200_M1 1e-15
C_coup_M1_4_2 2400_200_M1 2500_200_M1 1e-15
C_coup_M1_6_2 2600_200_M1 2700_200_M1 1e-15
C_coup_M1_8_2 2800_200_M1 2900_200_M1 1e-15
C_coup_M1_0_3 2000_300_M1 2100_300_M1 1e-15
C_coup_M1_2_3 2200_300_M1 2300_300_M1 1e-15
C_coup_M1_4_3 2400_300_M1 2500_300_M1 1e-15
C_coup_M1_6_3 2600_300_M1 2700_300_M1 1e-15
C_coup_M1_8_3 2800_300_M1 2900_300_M1 1e-15
C_coup_M1_0_4 2000_400_M1 2100_400_M1 1e-15
C_coup_M1_2_4 2200_400_M1 2300_400_M1 1e-15
C_coup_M1_4_4 2400_400_M1 2500_400_M1 1e-15
C_coup_M1_6_4 2600_400_M1 2700_400_M1 1e-15
C_coup_M1_8_4 2800_400_M1 2900_400_M1 1e-15
C_coup_M1_0_5 2000_500_M1 2100_500_M1 1e-15
C_coup_M1_2_5 2200_500_M1 2300_500_M1 1e-15
C_coup_M1_4_5 2400_500_M1 2500_500_M1 1e-15
C_coup_M1_6_5 2600_500_M1 2700_500_M1 1e-15
C_coup_M1_8_5 2800_500_M1 2900_500_M1 1e-15
C_coup_M1_0_6 2000_600_M1 2100_600_M1 1e-15
C_coup_M1_2_6 2200_600_M1 2300_600_M1 1e-15
C_coup_M1_4_6 2400_600_M1 2500_600_M1 1e-15
C_coup_M1_6_6 2600_600_M1 2700_600_M1 1e-15
C_coup_M1_8_6 2800_600_M1 2900_600_M1 1e-15
C_coup_M1_0_7 2000_700_M1 2100_700_M1 1e-15
C_coup_M1_2_7 2200_700_M1 2300_700_M1 1e-15
C_coup_M1_4_7 2400_700_M1 2500_700_M1 1e-15
C_coup_M1_6_7 2600_700_M1 2700_700_M1 1e-15
C_coup_M1_8_7 2800_700_M1 2900_700_M1 1e-15
C_coup_M1_0_8 2000_800_M1 2100_800_M1 1e-15
C_coup_M1_2_8 2200_800_M1 2300_800_M1 1e-15
C_coup_M1_4_8 2400_800_M1 2500_800_M1 1e-15
C_coup_M1_6_8 2600_800_M1 2700_800_M1 1e-15
C_coup_M1_8_8 2800_800_M1 2900_800_M1 1e-15
C_coup_M1_0_9 2000_900_M1 2100_900_M1 1e-15
C_coup_M1_2_9 2200_900_M1 2300_900_M1 1e-15
C_coup_M1_4_9 2400_900_M1 2500_900_M1 1e-15
C_coup_M1_6_9 2600_900_M1 2700_900_M1 1e-15
C_coup_M1_8_9 2800_900_M1 2900_900_M1 1e-15

* ========== Layer M2 ==========
* Horizontal resistors (R=5 Ohm)
R_h_M2_0_0 2000_0_M2 2100_0_M2 5
R_h_M2_1_0 2100_0_M2 2200_0_M2 5
R_h_M2_2_0 2200_0_M2 2300_0_M2 5
R_h_M2_3_0 2300_0_M2 2400_0_M2 5
R_h_M2_4_0 2400_0_M2 2500_0_M2 5
R_h_M2_5_0 2500_0_M2 2600_0_M2 5
R_h_M2_6_0 2600_0_M2 2700_0_M2 5
R_h_M2_7_0 2700_0_M2 2800_0_M2 5
R_h_M2_8_0 2800_0_M2 2900_0_M2 5
R_h_M2_0_1 2000_100_M2 2100_100_M2 5
R_h_M2_1_1 2100_100_M2 2200_100_M2 5
R_h_M2_2_1 2200_100_M2 2300_100_M2 5
R_h_M2_3_1 2300_100_M2 2400_100_M2 5
R_h_M2_4_1 2400_100_M2 2500_100_M2 5
R_h_M2_5_1 2500_100_M2 2600_100_M2 5
R_h_M2_6_1 2600_100_M2 2700_100_M2 5
R_h_M2_7_1 2700_100_M2 2800_100_M2 5
R_h_M2_8_1 2800_100_M2 2900_100_M2 5
R_h_M2_0_2 2000_200_M2 2100_200_M2 5
R_h_M2_1_2 2100_200_M2 2200_200_M2 5
R_h_M2_2_2 2200_200_M2 2300_200_M2 5
R_h_M2_3_2 2300_200_M2 2400_200_M2 5
R_h_M2_4_2 2400_200_M2 2500_200_M2 5
R_h_M2_5_2 2500_200_M2 2600_200_M2 5
R_h_M2_6_2 2600_200_M2 2700_200_M2 5
R_h_M2_7_2 2700_200_M2 2800_200_M2 5
R_h_M2_8_2 2800_200_M2 2900_200_M2 5
R_h_M2_0_3 2000_300_M2 2100_300_M2 5
R_h_M2_1_3 2100_300_M2 2200_300_M2 5
R_h_M2_2_3 2200_300_M2 2300_300_M2 5
R_h_M2_3_3 2300_300_M2 2400_300_M2 5
R_h_M2_4_3 2400_300_M2 2500_300_M2 5
R_h_M2_5_3 2500_300_M2 2600_300_M2 5
R_h_M2_6_3 2600_300_M2 2700_300_M2 5
R_h_M2_7_3 2700_300_M2 2800_300_M2 5
R_h_M2_8_3 2800_300_M2 2900_300_M2 5
R_h_M2_0_4 2000_400_M2 2100_400_M2 5
R_h_M2_1_4 2100_400_M2 2200_400_M2 5
R_h_M2_2_4 2200_400_M2 2300_400_M2 5
R_h_M2_3_4 2300_400_M2 2400_400_M2 5
R_h_M2_4_4 2400_400_M2 2500_400_M2 5
R_h_M2_5_4 2500_400_M2 2600_400_M2 5
R_h_M2_6_4 2600_400_M2 2700_400_M2 5
R_h_M2_7_4 2700_400_M2 2800_400_M2 5
R_h_M2_8_4 2800_400_M2 2900_400_M2 5
R_h_M2_0_5 2000_500_M2 2100_500_M2 5
R_h_M2_1_5 2100_500_M2 2200_500_M2 5
R_h_M2_2_5 2200_500_M2 2300_500_M2 5
R_h_M2_3_5 2300_500_M2 2400_500_M2 5
R_h_M2_4_5 2400_500_M2 2500_500_M2 5
R_h_M2_5_5 2500_500_M2 2600_500_M2 5
R_h_M2_6_5 2600_500_M2 2700_500_M2 5
R_h_M2_7_5 2700_500_M2 2800_500_M2 5
R_h_M2_8_5 2800_500_M2 2900_500_M2 5
R_h_M2_0_6 2000_600_M2 2100_600_M2 5
R_h_M2_1_6 2100_600_M2 2200_600_M2 5
R_h_M2_2_6 2200_600_M2 2300_600_M2 5
R_h_M2_3_6 2300_600_M2 2400_600_M2 5
R_h_M2_4_6 2400_600_M2 2500_600_M2 5
R_h_M2_5_6 2500_600_M2 2600_600_M2 5
R_h_M2_6_6 2600_600_M2 2700_600_M2 5
R_h_M2_7_6 2700_600_M2 2800_600_M2 5
R_h_M2_8_6 2800_600_M2 2900_600_M2 5
R_h_M2_0_7 2000_700_M2 2100_700_M2 5
R_h_M2_1_7 2100_700_M2 2200_700_M2 5
R_h_M2_2_7 2200_700_M2 2300_700_M2 5
R_h_M2_3_7 2300_700_M2 2400_700_M2 5
R_h_M2_4_7 2400_700_M2 2500_700_M2 5
R_h_M2_5_7 2500_700_M2 2600_700_M2 5
R_h_M2_6_7 2600_700_M2 2700_700_M2 5
R_h_M2_7_7 2700_700_M2 2800_700_M2 5
R_h_M2_8_7 2800_700_M2 2900_700_M2 5
R_h_M2_0_8 2000_800_M2 2100_800_M2 5
R_h_M2_1_8 2100_800_M2 2200_800_M2 5
R_h_M2_2_8 2200_800_M2 2300_800_M2 5
R_h_M2_3_8 2300_800_M2 2400_800_M2 5
R_h_M2_4_8 2400_800_M2 2500_800_M2 5
R_h_M2_5_8 2500_800_M2 2600_800_M2 5
R_h_M2_6_8 2600_800_M2 2700_800_M2 5
R_h_M2_7_8 2700_800_M2 2800_800_M2 5
R_h_M2_8_8 2800_800_M2 2900_800_M2 5
R_h_M2_0_9 2000_900_M2 2100_900_M2 5
R_h_M2_1_9 2100_900_M2 2200_900_M2 5
R_h_M2_2_9 2200_900_M2 2300_900_M2 5
R_h_M2_3_9 2300_900_M2 2400_900_M2 5
R_h_M2_4_9 2400_900_M2 2500_900_M2 5
R_h_M2_5_9 2500_900_M2 2600_900_M2 5
R_h_M2_6_9 2600_900_M2 2700_900_M2 5
R_h_M2_7_9 2700_900_M2 2800_900_M2 5
R_h_M2_8_9 2800_900_M2 2900_900_M2 5
* Vertical resistors (R=6 Ohm)
R_v_M2_0_0 2000_0_M2 2000_100_M2 6
R_v_M2_1_0 2100_0_M2 2100_100_M2 6
R_v_M2_2_0 2200_0_M2 2200_100_M2 6
R_v_M2_3_0 2300_0_M2 2300_100_M2 6
R_v_M2_4_0 2400_0_M2 2400_100_M2 6
R_v_M2_5_0 2500_0_M2 2500_100_M2 6
R_v_M2_6_0 2600_0_M2 2600_100_M2 6
R_v_M2_7_0 2700_0_M2 2700_100_M2 6
R_v_M2_8_0 2800_0_M2 2800_100_M2 6
R_v_M2_9_0 2900_0_M2 2900_100_M2 6
R_v_M2_0_1 2000_100_M2 2000_200_M2 6
R_v_M2_1_1 2100_100_M2 2100_200_M2 6
R_v_M2_2_1 2200_100_M2 2200_200_M2 6
R_v_M2_3_1 2300_100_M2 2300_200_M2 6
R_v_M2_4_1 2400_100_M2 2400_200_M2 6
R_v_M2_5_1 2500_100_M2 2500_200_M2 6
R_v_M2_6_1 2600_100_M2 2600_200_M2 6
R_v_M2_7_1 2700_100_M2 2700_200_M2 6
R_v_M2_8_1 2800_100_M2 2800_200_M2 6
R_v_M2_9_1 2900_100_M2 2900_200_M2 6
R_v_M2_0_2 2000_200_M2 2000_300_M2 6
R_v_M2_1_2 2100_200_M2 2100_300_M2 6
R_v_M2_2_2 2200_200_M2 2200_300_M2 6
R_v_M2_3_2 2300_200_M2 2300_300_M2 6
R_v_M2_4_2 2400_200_M2 2400_300_M2 6
R_v_M2_5_2 2500_200_M2 2500_300_M2 6
R_v_M2_6_2 2600_200_M2 2600_300_M2 6
R_v_M2_7_2 2700_200_M2 2700_300_M2 6
R_v_M2_8_2 2800_200_M2 2800_300_M2 6
R_v_M2_9_2 2900_200_M2 2900_300_M2 6
R_v_M2_0_3 2000_300_M2 2000_400_M2 6
R_v_M2_1_3 2100_300_M2 2100_400_M2 6
R_v_M2_2_3 2200_300_M2 2200_400_M2 6
R_v_M2_3_3 2300_300_M2 2300_400_M2 6
R_v_M2_4_3 2400_300_M2 2400_400_M2 6
R_v_M2_5_3 2500_300_M2 2500_400_M2 6
R_v_M2_6_3 2600_300_M2 2600_400_M2 6
R_v_M2_7_3 2700_300_M2 2700_400_M2 6
R_v_M2_8_3 2800_300_M2 2800_400_M2 6
R_v_M2_9_3 2900_300_M2 2900_400_M2 6
R_v_M2_0_4 2000_400_M2 2000_500_M2 6
R_v_M2_1_4 2100_400_M2 2100_500_M2 6
R_v_M2_2_4 2200_400_M2 2200_500_M2 6
R_v_M2_3_4 2300_400_M2 2300_500_M2 6
R_v_M2_4_4 2400_400_M2 2400_500_M2 6
R_v_M2_5_4 2500_400_M2 2500_500_M2 6
R_v_M2_6_4 2600_400_M2 2600_500_M2 6
R_v_M2_7_4 2700_400_M2 2700_500_M2 6
R_v_M2_8_4 2800_400_M2 2800_500_M2 6
R_v_M2_9_4 2900_400_M2 2900_500_M2 6
R_v_M2_0_5 2000_500_M2 2000_600_M2 6
R_v_M2_1_5 2100_500_M2 2100_600_M2 6
R_v_M2_2_5 2200_500_M2 2200_600_M2 6
R_v_M2_3_5 2300_500_M2 2300_600_M2 6
R_v_M2_4_5 2400_500_M2 2400_600_M2 6
R_v_M2_5_5 2500_500_M2 2500_600_M2 6
R_v_M2_6_5 2600_500_M2 2600_600_M2 6
R_v_M2_7_5 2700_500_M2 2700_600_M2 6
R_v_M2_8_5 2800_500_M2 2800_600_M2 6
R_v_M2_9_5 2900_500_M2 2900_600_M2 6
R_v_M2_0_6 2000_600_M2 2000_700_M2 6
R_v_M2_1_6 2100_600_M2 2100_700_M2 6
R_v_M2_2_6 2200_600_M2 2200_700_M2 6
R_v_M2_3_6 2300_600_M2 2300_700_M2 6
R_v_M2_4_6 2400_600_M2 2400_700_M2 6
R_v_M2_5_6 2500_600_M2 2500_700_M2 6
R_v_M2_6_6 2600_600_M2 2600_700_M2 6
R_v_M2_7_6 2700_600_M2 2700_700_M2 6
R_v_M2_8_6 2800_600_M2 2800_700_M2 6
R_v_M2_9_6 2900_600_M2 2900_700_M2 6
R_v_M2_0_7 2000_700_M2 2000_800_M2 6
R_v_M2_1_7 2100_700_M2 2100_800_M2 6
R_v_M2_2_7 2200_700_M2 2200_800_M2 6
R_v_M2_3_7 2300_700_M2 2300_800_M2 6
R_v_M2_4_7 2400_700_M2 2400_800_M2 6
R_v_M2_5_7 2500_700_M2 2500_800_M2 6
R_v_M2_6_7 2600_700_M2 2600_800_M2 6
R_v_M2_7_7 2700_700_M2 2700_800_M2 6
R_v_M2_8_7 2800_700_M2 2800_800_M2 6
R_v_M2_9_7 2900_700_M2 2900_800_M2 6
R_v_M2_0_8 2000_800_M2 2000_900_M2 6
R_v_M2_1_8 2100_800_M2 2100_900_M2 6
R_v_M2_2_8 2200_800_M2 2200_900_M2 6
R_v_M2_3_8 2300_800_M2 2300_900_M2 6
R_v_M2_4_8 2400_800_M2 2400_900_M2 6
R_v_M2_5_8 2500_800_M2 2500_900_M2 6
R_v_M2_6_8 2600_800_M2 2600_900_M2 6
R_v_M2_7_8 2700_800_M2 2700_900_M2 6
R_v_M2_8_8 2800_800_M2 2800_900_M2 6
R_v_M2_9_8 2900_800_M2 2900_900_M2 6
* Ground capacitors (C=3.0 fF)
C_g_M2_0_0 2000_0_M2 0 3e-15
C_g_M2_1_0 2100_0_M2 0 3e-15
C_g_M2_2_0 2200_0_M2 0 3e-15
C_g_M2_3_0 2300_0_M2 0 3e-15
C_g_M2_4_0 2400_0_M2 0 3e-15
C_g_M2_5_0 2500_0_M2 0 3e-15
C_g_M2_6_0 2600_0_M2 0 3e-15
C_g_M2_7_0 2700_0_M2 0 3e-15
C_g_M2_8_0 2800_0_M2 0 3e-15
C_g_M2_9_0 2900_0_M2 0 3e-15
C_g_M2_0_1 2000_100_M2 0 3e-15
C_g_M2_1_1 2100_100_M2 0 3e-15
C_g_M2_2_1 2200_100_M2 0 3e-15
C_g_M2_3_1 2300_100_M2 0 3e-15
C_g_M2_4_1 2400_100_M2 0 3e-15
C_g_M2_5_1 2500_100_M2 0 3e-15
C_g_M2_6_1 2600_100_M2 0 3e-15
C_g_M2_7_1 2700_100_M2 0 3e-15
C_g_M2_8_1 2800_100_M2 0 3e-15
C_g_M2_9_1 2900_100_M2 0 3e-15
C_g_M2_0_2 2000_200_M2 0 3e-15
C_g_M2_1_2 2100_200_M2 0 3e-15
C_g_M2_2_2 2200_200_M2 0 3e-15
C_g_M2_3_2 2300_200_M2 0 3e-15
C_g_M2_4_2 2400_200_M2 0 3e-15
C_g_M2_5_2 2500_200_M2 0 3e-15
C_g_M2_6_2 2600_200_M2 0 3e-15
C_g_M2_7_2 2700_200_M2 0 3e-15
C_g_M2_8_2 2800_200_M2 0 3e-15
C_g_M2_9_2 2900_200_M2 0 3e-15
C_g_M2_0_3 2000_300_M2 0 3e-15
C_g_M2_1_3 2100_300_M2 0 3e-15
C_g_M2_2_3 2200_300_M2 0 3e-15
C_g_M2_3_3 2300_300_M2 0 3e-15
C_g_M2_4_3 2400_300_M2 0 3e-15
C_g_M2_5_3 2500_300_M2 0 3e-15
C_g_M2_6_3 2600_300_M2 0 3e-15
C_g_M2_7_3 2700_300_M2 0 3e-15
C_g_M2_8_3 2800_300_M2 0 3e-15
C_g_M2_9_3 2900_300_M2 0 3e-15
C_g_M2_0_4 2000_400_M2 0 3e-15
C_g_M2_1_4 2100_400_M2 0 3e-15
C_g_M2_2_4 2200_400_M2 0 3e-15
C_g_M2_3_4 2300_400_M2 0 3e-15
C_g_M2_4_4 2400_400_M2 0 3e-15
C_g_M2_5_4 2500_400_M2 0 3e-15
C_g_M2_6_4 2600_400_M2 0 3e-15
C_g_M2_7_4 2700_400_M2 0 3e-15
C_g_M2_8_4 2800_400_M2 0 3e-15
C_g_M2_9_4 2900_400_M2 0 3e-15
C_g_M2_0_5 2000_500_M2 0 3e-15
C_g_M2_1_5 2100_500_M2 0 3e-15
C_g_M2_2_5 2200_500_M2 0 3e-15
C_g_M2_3_5 2300_500_M2 0 3e-15
C_g_M2_4_5 2400_500_M2 0 3e-15
C_g_M2_5_5 2500_500_M2 0 3e-15
C_g_M2_6_5 2600_500_M2 0 3e-15
C_g_M2_7_5 2700_500_M2 0 3e-15
C_g_M2_8_5 2800_500_M2 0 3e-15
C_g_M2_9_5 2900_500_M2 0 3e-15
C_g_M2_0_6 2000_600_M2 0 3e-15
C_g_M2_1_6 2100_600_M2 0 3e-15
C_g_M2_2_6 2200_600_M2 0 3e-15
C_g_M2_3_6 2300_600_M2 0 3e-15
C_g_M2_4_6 2400_600_M2 0 3e-15
C_g_M2_5_6 2500_600_M2 0 3e-15
C_g_M2_6_6 2600_600_M2 0 3e-15
C_g_M2_7_6 2700_600_M2 0 3e-15
C_g_M2_8_6 2800_600_M2 0 3e-15
C_g_M2_9_6 2900_600_M2 0 3e-15
C_g_M2_0_7 2000_700_M2 0 3e-15
C_g_M2_1_7 2100_700_M2 0 3e-15
C_g_M2_2_7 2200_700_M2 0 3e-15
C_g_M2_3_7 2300_700_M2 0 3e-15
C_g_M2_4_7 2400_700_M2 0 3e-15
C_g_M2_5_7 2500_700_M2 0 3e-15
C_g_M2_6_7 2600_700_M2 0 3e-15
C_g_M2_7_7 2700_700_M2 0 3e-15
C_g_M2_8_7 2800_700_M2 0 3e-15
C_g_M2_9_7 2900_700_M2 0 3e-15
C_g_M2_0_8 2000_800_M2 0 3e-15
C_g_M2_1_8 2100_800_M2 0 3e-15
C_g_M2_2_8 2200_800_M2 0 3e-15
C_g_M2_3_8 2300_800_M2 0 3e-15
C_g_M2_4_8 2400_800_M2 0 3e-15
C_g_M2_5_8 2500_800_M2 0 3e-15
C_g_M2_6_8 2600_800_M2 0 3e-15
C_g_M2_7_8 2700_800_M2 0 3e-15
C_g_M2_8_8 2800_800_M2 0 3e-15
C_g_M2_9_8 2900_800_M2 0 3e-15
C_g_M2_0_9 2000_900_M2 0 3e-15
C_g_M2_1_9 2100_900_M2 0 3e-15
C_g_M2_2_9 2200_900_M2 0 3e-15
C_g_M2_3_9 2300_900_M2 0 3e-15
C_g_M2_4_9 2400_900_M2 0 3e-15
C_g_M2_5_9 2500_900_M2 0 3e-15
C_g_M2_6_9 2600_900_M2 0 3e-15
C_g_M2_7_9 2700_900_M2 0 3e-15
C_g_M2_8_9 2800_900_M2 0 3e-15
C_g_M2_9_9 2900_900_M2 0 3e-15
* Coupling capacitors (C=1.0 fF)
C_coup_M2_0_0 2000_0_M2 2100_0_M2 1e-15
C_coup_M2_2_0 2200_0_M2 2300_0_M2 1e-15
C_coup_M2_4_0 2400_0_M2 2500_0_M2 1e-15
C_coup_M2_6_0 2600_0_M2 2700_0_M2 1e-15
C_coup_M2_8_0 2800_0_M2 2900_0_M2 1e-15
C_coup_M2_0_1 2000_100_M2 2100_100_M2 1e-15
C_coup_M2_2_1 2200_100_M2 2300_100_M2 1e-15
C_coup_M2_4_1 2400_100_M2 2500_100_M2 1e-15
C_coup_M2_6_1 2600_100_M2 2700_100_M2 1e-15
C_coup_M2_8_1 2800_100_M2 2900_100_M2 1e-15
C_coup_M2_0_2 2000_200_M2 2100_200_M2 1e-15
C_coup_M2_2_2 2200_200_M2 2300_200_M2 1e-15
C_coup_M2_4_2 2400_200_M2 2500_200_M2 1e-15
C_coup_M2_6_2 2600_200_M2 2700_200_M2 1e-15
C_coup_M2_8_2 2800_200_M2 2900_200_M2 1e-15
C_coup_M2_0_3 2000_300_M2 2100_300_M2 1e-15
C_coup_M2_2_3 2200_300_M2 2300_300_M2 1e-15
C_coup_M2_4_3 2400_300_M2 2500_300_M2 1e-15
C_coup_M2_6_3 2600_300_M2 2700_300_M2 1e-15
C_coup_M2_8_3 2800_300_M2 2900_300_M2 1e-15
C_coup_M2_0_4 2000_400_M2 2100_400_M2 1e-15
C_coup_M2_2_4 2200_400_M2 2300_400_M2 1e-15
C_coup_M2_4_4 2400_400_M2 2500_400_M2 1e-15
C_coup_M2_6_4 2600_400_M2 2700_400_M2 1e-15
C_coup_M2_8_4 2800_400_M2 2900_400_M2 1e-15
C_coup_M2_0_5 2000_500_M2 2100_500_M2 1e-15
C_coup_M2_2_5 2200_500_M2 2300_500_M2 1e-15
C_coup_M2_4_5 2400_500_M2 2500_500_M2 1e-15
C_coup_M2_6_5 2600_500_M2 2700_500_M2 1e-15
C_coup_M2_8_5 2800_500_M2 2900_500_M2 1e-15
C_coup_M2_0_6 2000_600_M2 2100_600_M2 1e-15
C_coup_M2_2_6 2200_600_M2 2300_600_M2 1e-15
C_coup_M2_4_6 2400_600_M2 2500_600_M2 1e-15
C_coup_M2_6_6 2600_600_M2 2700_600_M2 1e-15
C_coup_M2_8_6 2800_600_M2 2900_600_M2 1e-15
C_coup_M2_0_7 2000_700_M2 2100_700_M2 1e-15
C_coup_M2_2_7 2200_700_M2 2300_700_M2 1e-15
C_coup_M2_4_7 2400_700_M2 2500_700_M2 1e-15
C_coup_M2_6_7 2600_700_M2 2700_700_M2 1e-15
C_coup_M2_8_7 2800_700_M2 2900_700_M2 1e-15
C_coup_M2_0_8 2000_800_M2 2100_800_M2 1e-15
C_coup_M2_2_8 2200_800_M2 2300_800_M2 1e-15
C_coup_M2_4_8 2400_800_M2 2500_800_M2 1e-15
C_coup_M2_6_8 2600_800_M2 2700_800_M2 1e-15
C_coup_M2_8_8 2800_800_M2 2900_800_M2 1e-15
C_coup_M2_0_9 2000_900_M2 2100_900_M2 1e-15
C_coup_M2_2_9 2200_900_M2 2300_900_M2 1e-15
C_coup_M2_4_9 2400_900_M2 2500_900_M2 1e-15
C_coup_M2_6_9 2600_900_M2 2700_900_M2 1e-15
C_coup_M2_8_9 2800_900_M2 2900_900_M2 1e-15

* ========== Layer M3 ==========
* Horizontal resistors (R=3 Ohm)
R_h_M3_0_0 2000_0_M3 2100_0_M3 3
R_h_M3_1_0 2100_0_M3 2200_0_M3 3
R_h_M3_2_0 2200_0_M3 2300_0_M3 3
R_h_M3_3_0 2300_0_M3 2400_0_M3 3
R_h_M3_4_0 2400_0_M3 2500_0_M3 3
R_h_M3_5_0 2500_0_M3 2600_0_M3 3
R_h_M3_6_0 2600_0_M3 2700_0_M3 3
R_h_M3_7_0 2700_0_M3 2800_0_M3 3
R_h_M3_8_0 2800_0_M3 2900_0_M3 3
R_h_M3_0_1 2000_100_M3 2100_100_M3 3
R_h_M3_1_1 2100_100_M3 2200_100_M3 3
R_h_M3_2_1 2200_100_M3 2300_100_M3 3
R_h_M3_3_1 2300_100_M3 2400_100_M3 3
R_h_M3_4_1 2400_100_M3 2500_100_M3 3
R_h_M3_5_1 2500_100_M3 2600_100_M3 3
R_h_M3_6_1 2600_100_M3 2700_100_M3 3
R_h_M3_7_1 2700_100_M3 2800_100_M3 3
R_h_M3_8_1 2800_100_M3 2900_100_M3 3
R_h_M3_0_2 2000_200_M3 2100_200_M3 3
R_h_M3_1_2 2100_200_M3 2200_200_M3 3
R_h_M3_2_2 2200_200_M3 2300_200_M3 3
R_h_M3_3_2 2300_200_M3 2400_200_M3 3
R_h_M3_4_2 2400_200_M3 2500_200_M3 3
R_h_M3_5_2 2500_200_M3 2600_200_M3 3
R_h_M3_6_2 2600_200_M3 2700_200_M3 3
R_h_M3_7_2 2700_200_M3 2800_200_M3 3
R_h_M3_8_2 2800_200_M3 2900_200_M3 3
R_h_M3_0_3 2000_300_M3 2100_300_M3 3
R_h_M3_1_3 2100_300_M3 2200_300_M3 3
R_h_M3_2_3 2200_300_M3 2300_300_M3 3
R_h_M3_3_3 2300_300_M3 2400_300_M3 3
R_h_M3_4_3 2400_300_M3 2500_300_M3 3
R_h_M3_5_3 2500_300_M3 2600_300_M3 3
R_h_M3_6_3 2600_300_M3 2700_300_M3 3
R_h_M3_7_3 2700_300_M3 2800_300_M3 3
R_h_M3_8_3 2800_300_M3 2900_300_M3 3
R_h_M3_0_4 2000_400_M3 2100_400_M3 3
R_h_M3_1_4 2100_400_M3 2200_400_M3 3
R_h_M3_2_4 2200_400_M3 2300_400_M3 3
R_h_M3_3_4 2300_400_M3 2400_400_M3 3
R_h_M3_4_4 2400_400_M3 2500_400_M3 3
R_h_M3_5_4 2500_400_M3 2600_400_M3 3
R_h_M3_6_4 2600_400_M3 2700_400_M3 3
R_h_M3_7_4 2700_400_M3 2800_400_M3 3
R_h_M3_8_4 2800_400_M3 2900_400_M3 3
R_h_M3_0_5 2000_500_M3 2100_500_M3 3
R_h_M3_1_5 2100_500_M3 2200_500_M3 3
R_h_M3_2_5 2200_500_M3 2300_500_M3 3
R_h_M3_3_5 2300_500_M3 2400_500_M3 3
R_h_M3_4_5 2400_500_M3 2500_500_M3 3
R_h_M3_5_5 2500_500_M3 2600_500_M3 3
R_h_M3_6_5 2600_500_M3 2700_500_M3 3
R_h_M3_7_5 2700_500_M3 2800_500_M3 3
R_h_M3_8_5 2800_500_M3 2900_500_M3 3
R_h_M3_0_6 2000_600_M3 2100_600_M3 3
R_h_M3_1_6 2100_600_M3 2200_600_M3 3
R_h_M3_2_6 2200_600_M3 2300_600_M3 3
R_h_M3_3_6 2300_600_M3 2400_600_M3 3
R_h_M3_4_6 2400_600_M3 2500_600_M3 3
R_h_M3_5_6 2500_600_M3 2600_600_M3 3
R_h_M3_6_6 2600_600_M3 2700_600_M3 3
R_h_M3_7_6 2700_600_M3 2800_600_M3 3
R_h_M3_8_6 2800_600_M3 2900_600_M3 3
R_h_M3_0_7 2000_700_M3 2100_700_M3 3
R_h_M3_1_7 2100_700_M3 2200_700_M3 3
R_h_M3_2_7 2200_700_M3 2300_700_M3 3
R_h_M3_3_7 2300_700_M3 2400_700_M3 3
R_h_M3_4_7 2400_700_M3 2500_700_M3 3
R_h_M3_5_7 2500_700_M3 2600_700_M3 3
R_h_M3_6_7 2600_700_M3 2700_700_M3 3
R_h_M3_7_7 2700_700_M3 2800_700_M3 3
R_h_M3_8_7 2800_700_M3 2900_700_M3 3
R_h_M3_0_8 2000_800_M3 2100_800_M3 3
R_h_M3_1_8 2100_800_M3 2200_800_M3 3
R_h_M3_2_8 2200_800_M3 2300_800_M3 3
R_h_M3_3_8 2300_800_M3 2400_800_M3 3
R_h_M3_4_8 2400_800_M3 2500_800_M3 3
R_h_M3_5_8 2500_800_M3 2600_800_M3 3
R_h_M3_6_8 2600_800_M3 2700_800_M3 3
R_h_M3_7_8 2700_800_M3 2800_800_M3 3
R_h_M3_8_8 2800_800_M3 2900_800_M3 3
R_h_M3_0_9 2000_900_M3 2100_900_M3 3
R_h_M3_1_9 2100_900_M3 2200_900_M3 3
R_h_M3_2_9 2200_900_M3 2300_900_M3 3
R_h_M3_3_9 2300_900_M3 2400_900_M3 3
R_h_M3_4_9 2400_900_M3 2500_900_M3 3
R_h_M3_5_9 2500_900_M3 2600_900_M3 3
R_h_M3_6_9 2600_900_M3 2700_900_M3 3
R_h_M3_7_9 2700_900_M3 2800_900_M3 3
R_h_M3_8_9 2800_900_M3 2900_900_M3 3
* Vertical resistors (R=4 Ohm)
R_v_M3_0_0 2000_0_M3 2000_100_M3 4
R_v_M3_1_0 2100_0_M3 2100_100_M3 4
R_v_M3_2_0 2200_0_M3 2200_100_M3 4
R_v_M3_3_0 2300_0_M3 2300_100_M3 4
R_v_M3_4_0 2400_0_M3 2400_100_M3 4
R_v_M3_5_0 2500_0_M3 2500_100_M3 4
R_v_M3_6_0 2600_0_M3 2600_100_M3 4
R_v_M3_7_0 2700_0_M3 2700_100_M3 4
R_v_M3_8_0 2800_0_M3 2800_100_M3 4
R_v_M3_9_0 2900_0_M3 2900_100_M3 4
R_v_M3_0_1 2000_100_M3 2000_200_M3 4
R_v_M3_1_1 2100_100_M3 2100_200_M3 4
R_v_M3_2_1 2200_100_M3 2200_200_M3 4
R_v_M3_3_1 2300_100_M3 2300_200_M3 4
R_v_M3_4_1 2400_100_M3 2400_200_M3 4
R_v_M3_5_1 2500_100_M3 2500_200_M3 4
R_v_M3_6_1 2600_100_M3 2600_200_M3 4
R_v_M3_7_1 2700_100_M3 2700_200_M3 4
R_v_M3_8_1 2800_100_M3 2800_200_M3 4
R_v_M3_9_1 2900_100_M3 2900_200_M3 4
R_v_M3_0_2 2000_200_M3 2000_300_M3 4
R_v_M3_1_2 2100_200_M3 2100_300_M3 4
R_v_M3_2_2 2200_200_M3 2200_300_M3 4
R_v_M3_3_2 2300_200_M3 2300_300_M3 4
R_v_M3_4_2 2400_200_M3 2400_300_M3 4
R_v_M3_5_2 2500_200_M3 2500_300_M3 4
R_v_M3_6_2 2600_200_M3 2600_300_M3 4
R_v_M3_7_2 2700_200_M3 2700_300_M3 4
R_v_M3_8_2 2800_200_M3 2800_300_M3 4
R_v_M3_9_2 2900_200_M3 2900_300_M3 4
R_v_M3_0_3 2000_300_M3 2000_400_M3 4
R_v_M3_1_3 2100_300_M3 2100_400_M3 4
R_v_M3_2_3 2200_300_M3 2200_400_M3 4
R_v_M3_3_3 2300_300_M3 2300_400_M3 4
R_v_M3_4_3 2400_300_M3 2400_400_M3 4
R_v_M3_5_3 2500_300_M3 2500_400_M3 4
R_v_M3_6_3 2600_300_M3 2600_400_M3 4
R_v_M3_7_3 2700_300_M3 2700_400_M3 4
R_v_M3_8_3 2800_300_M3 2800_400_M3 4
R_v_M3_9_3 2900_300_M3 2900_400_M3 4
R_v_M3_0_4 2000_400_M3 2000_500_M3 4
R_v_M3_1_4 2100_400_M3 2100_500_M3 4
R_v_M3_2_4 2200_400_M3 2200_500_M3 4
R_v_M3_3_4 2300_400_M3 2300_500_M3 4
R_v_M3_4_4 2400_400_M3 2400_500_M3 4
R_v_M3_5_4 2500_400_M3 2500_500_M3 4
R_v_M3_6_4 2600_400_M3 2600_500_M3 4
R_v_M3_7_4 2700_400_M3 2700_500_M3 4
R_v_M3_8_4 2800_400_M3 2800_500_M3 4
R_v_M3_9_4 2900_400_M3 2900_500_M3 4
R_v_M3_0_5 2000_500_M3 2000_600_M3 4
R_v_M3_1_5 2100_500_M3 2100_600_M3 4
R_v_M3_2_5 2200_500_M3 2200_600_M3 4
R_v_M3_3_5 2300_500_M3 2300_600_M3 4
R_v_M3_4_5 2400_500_M3 2400_600_M3 4
R_v_M3_5_5 2500_500_M3 2500_600_M3 4
R_v_M3_6_5 2600_500_M3 2600_600_M3 4
R_v_M3_7_5 2700_500_M3 2700_600_M3 4
R_v_M3_8_5 2800_500_M3 2800_600_M3 4
R_v_M3_9_5 2900_500_M3 2900_600_M3 4
R_v_M3_0_6 2000_600_M3 2000_700_M3 4
R_v_M3_1_6 2100_600_M3 2100_700_M3 4
R_v_M3_2_6 2200_600_M3 2200_700_M3 4
R_v_M3_3_6 2300_600_M3 2300_700_M3 4
R_v_M3_4_6 2400_600_M3 2400_700_M3 4
R_v_M3_5_6 2500_600_M3 2500_700_M3 4
R_v_M3_6_6 2600_600_M3 2600_700_M3 4
R_v_M3_7_6 2700_600_M3 2700_700_M3 4
R_v_M3_8_6 2800_600_M3 2800_700_M3 4
R_v_M3_9_6 2900_600_M3 2900_700_M3 4
R_v_M3_0_7 2000_700_M3 2000_800_M3 4
R_v_M3_1_7 2100_700_M3 2100_800_M3 4
R_v_M3_2_7 2200_700_M3 2200_800_M3 4
R_v_M3_3_7 2300_700_M3 2300_800_M3 4
R_v_M3_4_7 2400_700_M3 2400_800_M3 4
R_v_M3_5_7 2500_700_M3 2500_800_M3 4
R_v_M3_6_7 2600_700_M3 2600_800_M3 4
R_v_M3_7_7 2700_700_M3 2700_800_M3 4
R_v_M3_8_7 2800_700_M3 2800_800_M3 4
R_v_M3_9_7 2900_700_M3 2900_800_M3 4
R_v_M3_0_8 2000_800_M3 2000_900_M3 4
R_v_M3_1_8 2100_800_M3 2100_900_M3 4
R_v_M3_2_8 2200_800_M3 2200_900_M3 4
R_v_M3_3_8 2300_800_M3 2300_900_M3 4
R_v_M3_4_8 2400_800_M3 2400_900_M3 4
R_v_M3_5_8 2500_800_M3 2500_900_M3 4
R_v_M3_6_8 2600_800_M3 2600_900_M3 4
R_v_M3_7_8 2700_800_M3 2700_900_M3 4
R_v_M3_8_8 2800_800_M3 2800_900_M3 4
R_v_M3_9_8 2900_800_M3 2900_900_M3 4
* Ground capacitors (C=2.0 fF)
C_g_M3_0_0 2000_0_M3 0 2e-15
C_g_M3_1_0 2100_0_M3 0 2e-15
C_g_M3_2_0 2200_0_M3 0 2e-15
C_g_M3_3_0 2300_0_M3 0 2e-15
C_g_M3_4_0 2400_0_M3 0 2e-15
C_g_M3_5_0 2500_0_M3 0 2e-15
C_g_M3_6_0 2600_0_M3 0 2e-15
C_g_M3_7_0 2700_0_M3 0 2e-15
C_g_M3_8_0 2800_0_M3 0 2e-15
C_g_M3_9_0 2900_0_M3 0 2e-15
C_g_M3_0_1 2000_100_M3 0 2e-15
C_g_M3_1_1 2100_100_M3 0 2e-15
C_g_M3_2_1 2200_100_M3 0 2e-15
C_g_M3_3_1 2300_100_M3 0 2e-15
C_g_M3_4_1 2400_100_M3 0 2e-15
C_g_M3_5_1 2500_100_M3 0 2e-15
C_g_M3_6_1 2600_100_M3 0 2e-15
C_g_M3_7_1 2700_100_M3 0 2e-15
C_g_M3_8_1 2800_100_M3 0 2e-15
C_g_M3_9_1 2900_100_M3 0 2e-15
C_g_M3_0_2 2000_200_M3 0 2e-15
C_g_M3_1_2 2100_200_M3 0 2e-15
C_g_M3_2_2 2200_200_M3 0 2e-15
C_g_M3_3_2 2300_200_M3 0 2e-15
C_g_M3_4_2 2400_200_M3 0 2e-15
C_g_M3_5_2 2500_200_M3 0 2e-15
C_g_M3_6_2 2600_200_M3 0 2e-15
C_g_M3_7_2 2700_200_M3 0 2e-15
C_g_M3_8_2 2800_200_M3 0 2e-15
C_g_M3_9_2 2900_200_M3 0 2e-15
C_g_M3_0_3 2000_300_M3 0 2e-15
C_g_M3_1_3 2100_300_M3 0 2e-15
C_g_M3_2_3 2200_300_M3 0 2e-15
C_g_M3_3_3 2300_300_M3 0 2e-15
C_g_M3_4_3 2400_300_M3 0 2e-15
C_g_M3_5_3 2500_300_M3 0 2e-15
C_g_M3_6_3 2600_300_M3 0 2e-15
C_g_M3_7_3 2700_300_M3 0 2e-15
C_g_M3_8_3 2800_300_M3 0 2e-15
C_g_M3_9_3 2900_300_M3 0 2e-15
C_g_M3_0_4 2000_400_M3 0 2e-15
C_g_M3_1_4 2100_400_M3 0 2e-15
C_g_M3_2_4 2200_400_M3 0 2e-15
C_g_M3_3_4 2300_400_M3 0 2e-15
C_g_M3_4_4 2400_400_M3 0 2e-15
C_g_M3_5_4 2500_400_M3 0 2e-15
C_g_M3_6_4 2600_400_M3 0 2e-15
C_g_M3_7_4 2700_400_M3 0 2e-15
C_g_M3_8_4 2800_400_M3 0 2e-15
C_g_M3_9_4 2900_400_M3 0 2e-15
C_g_M3_0_5 2000_500_M3 0 2e-15
C_g_M3_1_5 2100_500_M3 0 2e-15
C_g_M3_2_5 2200_500_M3 0 2e-15
C_g_M3_3_5 2300_500_M3 0 2e-15
C_g_M3_4_5 2400_500_M3 0 2e-15
C_g_M3_5_5 2500_500_M3 0 2e-15
C_g_M3_6_5 2600_500_M3 0 2e-15
C_g_M3_7_5 2700_500_M3 0 2e-15
C_g_M3_8_5 2800_500_M3 0 2e-15
C_g_M3_9_5 2900_500_M3 0 2e-15
C_g_M3_0_6 2000_600_M3 0 2e-15
C_g_M3_1_6 2100_600_M3 0 2e-15
C_g_M3_2_6 2200_600_M3 0 2e-15
C_g_M3_3_6 2300_600_M3 0 2e-15
C_g_M3_4_6 2400_600_M3 0 2e-15
C_g_M3_5_6 2500_600_M3 0 2e-15
C_g_M3_6_6 2600_600_M3 0 2e-15
C_g_M3_7_6 2700_600_M3 0 2e-15
C_g_M3_8_6 2800_600_M3 0 2e-15
C_g_M3_9_6 2900_600_M3 0 2e-15
C_g_M3_0_7 2000_700_M3 0 2e-15
C_g_M3_1_7 2100_700_M3 0 2e-15
C_g_M3_2_7 2200_700_M3 0 2e-15
C_g_M3_3_7 2300_700_M3 0 2e-15
C_g_M3_4_7 2400_700_M3 0 2e-15
C_g_M3_5_7 2500_700_M3 0 2e-15
C_g_M3_6_7 2600_700_M3 0 2e-15
C_g_M3_7_7 2700_700_M3 0 2e-15
C_g_M3_8_7 2800_700_M3 0 2e-15
C_g_M3_9_7 2900_700_M3 0 2e-15
C_g_M3_0_8 2000_800_M3 0 2e-15
C_g_M3_1_8 2100_800_M3 0 2e-15
C_g_M3_2_8 2200_800_M3 0 2e-15
C_g_M3_3_8 2300_800_M3 0 2e-15
C_g_M3_4_8 2400_800_M3 0 2e-15
C_g_M3_5_8 2500_800_M3 0 2e-15
C_g_M3_6_8 2600_800_M3 0 2e-15
C_g_M3_7_8 2700_800_M3 0 2e-15
C_g_M3_8_8 2800_800_M3 0 2e-15
C_g_M3_9_8 2900_800_M3 0 2e-15
C_g_M3_0_9 2000_900_M3 0 2e-15
C_g_M3_1_9 2100_900_M3 0 2e-15
C_g_M3_2_9 2200_900_M3 0 2e-15
C_g_M3_3_9 2300_900_M3 0 2e-15
C_g_M3_4_9 2400_900_M3 0 2e-15
C_g_M3_5_9 2500_900_M3 0 2e-15
C_g_M3_6_9 2600_900_M3 0 2e-15
C_g_M3_7_9 2700_900_M3 0 2e-15
C_g_M3_8_9 2800_900_M3 0 2e-15
C_g_M3_9_9 2900_900_M3 0 2e-15
* Coupling capacitors (C=1.0 fF)
C_coup_M3_0_0 2000_0_M3 2100_0_M3 1e-15
C_coup_M3_2_0 2200_0_M3 2300_0_M3 1e-15
C_coup_M3_4_0 2400_0_M3 2500_0_M3 1e-15
C_coup_M3_6_0 2600_0_M3 2700_0_M3 1e-15
C_coup_M3_8_0 2800_0_M3 2900_0_M3 1e-15
C_coup_M3_0_1 2000_100_M3 2100_100_M3 1e-15
C_coup_M3_2_1 2200_100_M3 2300_100_M3 1e-15
C_coup_M3_4_1 2400_100_M3 2500_100_M3 1e-15
C_coup_M3_6_1 2600_100_M3 2700_100_M3 1e-15
C_coup_M3_8_1 2800_100_M3 2900_100_M3 1e-15
C_coup_M3_0_2 2000_200_M3 2100_200_M3 1e-15
C_coup_M3_2_2 2200_200_M3 2300_200_M3 1e-15
C_coup_M3_4_2 2400_200_M3 2500_200_M3 1e-15
C_coup_M3_6_2 2600_200_M3 2700_200_M3 1e-15
C_coup_M3_8_2 2800_200_M3 2900_200_M3 1e-15
C_coup_M3_0_3 2000_300_M3 2100_300_M3 1e-15
C_coup_M3_2_3 2200_300_M3 2300_300_M3 1e-15
C_coup_M3_4_3 2400_300_M3 2500_300_M3 1e-15
C_coup_M3_6_3 2600_300_M3 2700_300_M3 1e-15
C_coup_M3_8_3 2800_300_M3 2900_300_M3 1e-15
C_coup_M3_0_4 2000_400_M3 2100_400_M3 1e-15
C_coup_M3_2_4 2200_400_M3 2300_400_M3 1e-15
C_coup_M3_4_4 2400_400_M3 2500_400_M3 1e-15
C_coup_M3_6_4 2600_400_M3 2700_400_M3 1e-15
C_coup_M3_8_4 2800_400_M3 2900_400_M3 1e-15
C_coup_M3_0_5 2000_500_M3 2100_500_M3 1e-15
C_coup_M3_2_5 2200_500_M3 2300_500_M3 1e-15
C_coup_M3_4_5 2400_500_M3 2500_500_M3 1e-15
C_coup_M3_6_5 2600_500_M3 2700_500_M3 1e-15
C_coup_M3_8_5 2800_500_M3 2900_500_M3 1e-15
C_coup_M3_0_6 2000_600_M3 2100_600_M3 1e-15
C_coup_M3_2_6 2200_600_M3 2300_600_M3 1e-15
C_coup_M3_4_6 2400_600_M3 2500_600_M3 1e-15
C_coup_M3_6_6 2600_600_M3 2700_600_M3 1e-15
C_coup_M3_8_6 2800_600_M3 2900_600_M3 1e-15
C_coup_M3_0_7 2000_700_M3 2100_700_M3 1e-15
C_coup_M3_2_7 2200_700_M3 2300_700_M3 1e-15
C_coup_M3_4_7 2400_700_M3 2500_700_M3 1e-15
C_coup_M3_6_7 2600_700_M3 2700_700_M3 1e-15
C_coup_M3_8_7 2800_700_M3 2900_700_M3 1e-15
C_coup_M3_0_8 2000_800_M3 2100_800_M3 1e-15
C_coup_M3_2_8 2200_800_M3 2300_800_M3 1e-15
C_coup_M3_4_8 2400_800_M3 2500_800_M3 1e-15
C_coup_M3_6_8 2600_800_M3 2700_800_M3 1e-15
C_coup_M3_8_8 2800_800_M3 2900_800_M3 1e-15
C_coup_M3_0_9 2000_900_M3 2100_900_M3 1e-15
C_coup_M3_2_9 2200_900_M3 2300_900_M3 1e-15
C_coup_M3_4_9 2400_900_M3 2500_900_M3 1e-15
C_coup_M3_6_9 2600_900_M3 2700_900_M3 1e-15
C_coup_M3_8_9 2800_900_M3 2900_900_M3 1e-15

* ========== Via connections ==========
* Vias M1 to M2 (R=0.5 Ohm)
R_via_M1_M2_0_0 2000_0_M1 2000_0_M2 0.5
R_via_M1_M2_2_0 2200_0_M1 2200_0_M2 0.5
R_via_M1_M2_4_0 2400_0_M1 2400_0_M2 0.5
R_via_M1_M2_6_0 2600_0_M1 2600_0_M2 0.5
R_via_M1_M2_8_0 2800_0_M1 2800_0_M2 0.5
R_via_M1_M2_0_2 2000_200_M1 2000_200_M2 0.5
R_via_M1_M2_2_2 2200_200_M1 2200_200_M2 0.5
R_via_M1_M2_4_2 2400_200_M1 2400_200_M2 0.5
R_via_M1_M2_6_2 2600_200_M1 2600_200_M2 0.5
R_via_M1_M2_8_2 2800_200_M1 2800_200_M2 0.5
R_via_M1_M2_0_4 2000_400_M1 2000_400_M2 0.5
R_via_M1_M2_2_4 2200_400_M1 2200_400_M2 0.5
R_via_M1_M2_4_4 2400_400_M1 2400_400_M2 0.5
R_via_M1_M2_6_4 2600_400_M1 2600_400_M2 0.5
R_via_M1_M2_8_4 2800_400_M1 2800_400_M2 0.5
R_via_M1_M2_0_6 2000_600_M1 2000_600_M2 0.5
R_via_M1_M2_2_6 2200_600_M1 2200_600_M2 0.5
R_via_M1_M2_4_6 2400_600_M1 2400_600_M2 0.5
R_via_M1_M2_6_6 2600_600_M1 2600_600_M2 0.5
R_via_M1_M2_8_6 2800_600_M1 2800_600_M2 0.5
R_via_M1_M2_0_8 2000_800_M1 2000_800_M2 0.5
R_via_M1_M2_2_8 2200_800_M1 2200_800_M2 0.5
R_via_M1_M2_4_8 2400_800_M1 2400_800_M2 0.5
R_via_M1_M2_6_8 2600_800_M1 2600_800_M2 0.5
R_via_M1_M2_8_8 2800_800_M1 2800_800_M2 0.5
* Vias M2 to M3 (R=0.3 Ohm)
R_via_M2_M3_0_0 2000_0_M2 2000_0_M3 0.3
R_via_M2_M3_2_0 2200_0_M2 2200_0_M3 0.3
R_via_M2_M3_4_0 2400_0_M2 2400_0_M3 0.3
R_via_M2_M3_6_0 2600_0_M2 2600_0_M3 0.3
R_via_M2_M3_8_0 2800_0_M2 2800_0_M3 0.3
R_via_M2_M3_0_2 2000_200_M2 2000_200_M3 0.3
R_via_M2_M3_2_2 2200_200_M2 2200_200_M3 0.3
R_via_M2_M3_4_2 2400_200_M2 2400_200_M3 0.3
R_via_M2_M3_6_2 2600_200_M2 2600_200_M3 0.3
R_via_M2_M3_8_2 2800_200_M2 2800_200_M3 0.3
R_via_M2_M3_0_4 2000_400_M2 2000_400_M3 0.3
R_via_M2_M3_2_4 2200_400_M2 2200_400_M3 0.3
R_via_M2_M3_4_4 2400_400_M2 2400_400_M3 0.3
R_via_M2_M3_6_4 2600_400_M2 2600_400_M3 0.3
R_via_M2_M3_8_4 2800_400_M2 2800_400_M3 0.3
R_via_M2_M3_0_6 2000_600_M2 2000_600_M3 0.3
R_via_M2_M3_2_6 2200_600_M2 2200_600_M3 0.3
R_via_M2_M3_4_6 2400_600_M2 2400_600_M3 0.3
R_via_M2_M3_6_6 2600_600_M2 2600_600_M3 0.3
R_via_M2_M3_8_6 2800_600_M2 2800_600_M3 0.3
R_via_M2_M3_0_8 2000_800_M2 2000_800_M3 0.3
R_via_M2_M3_2_8 2200_800_M2 2200_800_M3 0.3
R_via_M2_M3_4_8 2400_800_M2 2400_800_M3 0.3
R_via_M2_M3_6_8 2600_800_M2 2600_800_M3 0.3
R_via_M2_M3_8_8 2800_800_M2 2800_800_M3 0.3

* ========== Decoupling capacitors ==========
C_decap_1_1 2100_100_M1 0 2e-13
C_decap_4_1 2400_100_M1 0 5e-14
C_decap_7_1 2700_100_M1 0 2e-13
C_decap_1_4 2100_400_M1 0 5e-14
C_decap_4_4 2400_400_M1 0 2e-13
C_decap_7_4 2700_400_M1 0 5e-14
C_decap_1_7 2100_700_M1 0 2e-13
C_decap_4_7 2400_700_M1 0 5e-14
C_decap_7_7 2700_700_M1 0 2e-13
* (9 decaps placed)

* ========== Boundary connections ==========
* Top boundary to tile_2_1
R_bnd_t_M1_0 *2000_900_M1 *2000_1000_M1 10
R_bnd_t_M2_0 *2000_900_M2 *2000_1000_M2 6
R_bnd_t_M3_0 *2000_900_M3 *2000_1000_M3 4
R_bnd_t_M1_1 *2100_900_M1 *2100_1000_M1 10
R_bnd_t_M2_1 *2100_900_M2 *2100_1000_M2 6
R_bnd_t_M3_1 *2100_900_M3 *2100_1000_M3 4
R_bnd_t_M1_2 *2200_900_M1 *2200_1000_M1 10
R_bnd_t_M2_2 *2200_900_M2 *2200_1000_M2 6
R_bnd_t_M3_2 *2200_900_M3 *2200_1000_M3 4
R_bnd_t_M1_3 *2300_900_M1 *2300_1000_M1 10
R_bnd_t_M2_3 *2300_900_M2 *2300_1000_M2 6
R_bnd_t_M3_3 *2300_900_M3 *2300_1000_M3 4
R_bnd_t_M1_4 *2400_900_M1 *2400_1000_M1 10
R_bnd_t_M2_4 *2400_900_M2 *2400_1000_M2 6
R_bnd_t_M3_4 *2400_900_M3 *2400_1000_M3 4
R_bnd_t_M1_5 *2500_900_M1 *2500_1000_M1 10
R_bnd_t_M2_5 *2500_900_M2 *2500_1000_M2 6
R_bnd_t_M3_5 *2500_900_M3 *2500_1000_M3 4
R_bnd_t_M1_6 *2600_900_M1 *2600_1000_M1 10
R_bnd_t_M2_6 *2600_900_M2 *2600_1000_M2 6
R_bnd_t_M3_6 *2600_900_M3 *2600_1000_M3 4
R_bnd_t_M1_7 *2700_900_M1 *2700_1000_M1 10
R_bnd_t_M2_7 *2700_900_M2 *2700_1000_M2 6
R_bnd_t_M3_7 *2700_900_M3 *2700_1000_M3 4
R_bnd_t_M1_8 *2800_900_M1 *2800_1000_M1 10
R_bnd_t_M2_8 *2800_900_M2 *2800_1000_M2 6
R_bnd_t_M3_8 *2800_900_M3 *2800_1000_M3 4
R_bnd_t_M1_9 *2900_900_M1 *2900_1000_M1 10
R_bnd_t_M2_9 *2900_900_M2 *2900_1000_M2 6
R_bnd_t_M3_9 *2900_900_M3 *2900_1000_M3 4

* Tile 2_0 summary: 620 R, 459 C
