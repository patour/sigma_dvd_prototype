* Instance models for tile 1_1
* Current sources with static and dynamic currents
* Some nodes have multiple current sources (overlapping)

I_1_1_7_9 1700_1900_M1 0 1.5545e-03
I_1_1_0_6 1000_1600_M1 0 6.1782e-04 static_value=6.1243e-04
I_1_1_7_9_2 1700_1900_M1 0 0 pulse(4.6196e-04, 2.5757e-03, 1.2501e-09, 3.6447e-10, 4.7347e-10, 3.2754e-09, 1.1812e-08)
I_1_1_3_1 1300_1100_M1 0 0 pwl(0.0000e+00 2.2710e-03 2.6533e-09 1.7852e-04 3.9851e-09 7.6903e-04 6.4830e-09 1.4230e-03 8.0602e-09 3.1088e-04) pwl_period=1.2137e-08
I_1_1_9_7 1900_1700_M1 0 4.8280e-04 pulse(0, 1.0005e-03, 0, 0.2n, 0.2n, 4.4814e-09, 1.0804e-08)
I_1_1_1_5 1100_1500_M1 0 1.1196e-04 pwl(0 0 2n 7.1601e-04 5n 1.3223e-03 8n 4.2518e-04) pwl_period=10n
I_1_1_7_1 1700_1100_M1 0 6.3699e-04
I_1_1_5_3 1500_1300_M1 0 9.7334e-04 static_value=7.0158e-04
I_1_1_7_6 1700_1600_M1 0 0 pulse(2.8760e-04, 2.9016e-03, 1.9991e-09, 3.6891e-10, 2.0780e-10, 2.1207e-09, 1.3294e-08)
I_1_1_1_5_2 1100_1500_M1 0 0 pwl(0.0000e+00 1.2974e-03 1.8845e-09 6.9539e-04 4.8783e-09 1.0897e-03 7.5068e-09 2.4226e-03 9.4469e-09 1.0209e-03 1.1089e-08 2.6150e-04 1.2411e-08 1.0291e-03) pwl_period=1.6064e-08
I_1_1_0_9 1000_1900_M1 0 3.2014e-04 pulse(0, 1.2605e-03, 0, 0.2n, 0.2n, 3.1101e-09, 1.0881e-08)
I_1_1_7_7 1700_1700_M1 0 1.7572e-04 pwl(0 0 2n 5.5796e-04 5n 1.7725e-03 8n 7.3246e-04) pwl_period=10n
I_1_1_7_3 1700_1300_M1 0 1.7374e-03
I_1_1_1_0 1100_1000_M1 0 3.0081e-04 static_value=7.2162e-04
I_1_1_8_7 1800_1700_M1 0 0 pulse(2.3099e-04, 1.1084e-03, 1.0369e-09, 3.4905e-10, 2.9940e-10, 3.3261e-09, 8.3613e-09)
I_1_1_3_8 1300_1800_M1 0 0 pwl(0.0000e+00 1.3730e-03 2.8553e-09 1.0953e-03 5.2518e-09 3.0357e-04 8.1981e-09 1.5222e-03 9.6767e-09 3.9595e-04 1.1778e-08 1.3806e-03) pwl_period=1.4957e-08
I_1_1_1_9 1100_1900_M1 0 4.7388e-04 pulse(0, 9.6145e-04, 0, 0.2n, 0.2n, 3.3524e-09, 1.8321e-08)
I_1_1_8_0 1800_1000_M1 0 2.4951e-04 pwl(0 0 2n 8.5830e-04 5n 1.5089e-03 8n 4.3671e-04) pwl_period=10n
I_1_1_1_0_2 1100_1000_M1 0 1.7521e-03
I_1_1_7_7_2 1700_1700_M1 0 9.8617e-04 static_value=3.4624e-04
I_1_1_3_8_2 1300_1800_M1 0 0 pulse(2.7563e-04, 1.7672e-03, 1.8437e-09, 3.0330e-10, 4.5173e-10, 4.5921e-09, 9.9337e-09)
I_1_1_7_2 1700_1200_M1 0 0 pwl(0.0000e+00 8.4969e-04 2.5754e-09 6.6793e-04 3.5806e-09 1.8151e-03 6.2555e-09 1.4498e-03 8.5754e-09 2.1632e-03 1.0468e-08 1.2109e-03 1.2133e-08 1.9072e-03) pwl_period=1.5821e-08
I_1_1_8_7_2 1800_1700_M1 0 4.6088e-04 pulse(0, 1.4808e-03, 0, 0.2n, 0.2n, 3.7164e-09, 1.3830e-08)
I_1_1_1_9_2 1100_1900_M1 0 3.5680e-04 pwl(0 0 2n 7.0539e-04 5n 1.3182e-03 8n 5.3649e-04) pwl_period=10n
I_1_1_3_8_3 1300_1800_M1 0 1.8701e-03

* Tile 1_1 summary:
*   Total current sources: 25
*   With static current: 17
*   With waveforms: 16
*   Overlapping nodes: 8
