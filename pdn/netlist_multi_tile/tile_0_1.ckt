* Tile 0_1 netlist
* Multi-layer routing with R, C elements
* Includes ground caps, coupling caps, and decaps

* ========== Layer M1 ==========
* Horizontal resistors (R=8 Ohm)
R_h_M1_0_0 0_1000_M1 100_1000_M1 8
R_h_M1_1_0 100_1000_M1 200_1000_M1 8
R_h_M1_2_0 200_1000_M1 300_1000_M1 8
R_h_M1_3_0 300_1000_M1 400_1000_M1 8
R_h_M1_4_0 400_1000_M1 500_1000_M1 8
R_h_M1_5_0 500_1000_M1 600_1000_M1 8
R_h_M1_6_0 600_1000_M1 700_1000_M1 8
R_h_M1_7_0 700_1000_M1 800_1000_M1 8
R_h_M1_8_0 800_1000_M1 900_1000_M1 8
R_h_M1_0_1 0_1100_M1 100_1100_M1 8
R_h_M1_1_1 100_1100_M1 200_1100_M1 8
R_h_M1_2_1 200_1100_M1 300_1100_M1 8
R_h_M1_3_1 300_1100_M1 400_1100_M1 8
R_h_M1_4_1 400_1100_M1 500_1100_M1 8
R_h_M1_5_1 500_1100_M1 600_1100_M1 8
R_h_M1_6_1 600_1100_M1 700_1100_M1 8
R_h_M1_7_1 700_1100_M1 800_1100_M1 8
R_h_M1_8_1 800_1100_M1 900_1100_M1 8
R_h_M1_0_2 0_1200_M1 100_1200_M1 8
R_h_M1_1_2 100_1200_M1 200_1200_M1 8
R_h_M1_2_2 200_1200_M1 300_1200_M1 8
R_h_M1_3_2 300_1200_M1 400_1200_M1 8
R_h_M1_4_2 400_1200_M1 500_1200_M1 8
R_h_M1_5_2 500_1200_M1 600_1200_M1 8
R_h_M1_6_2 600_1200_M1 700_1200_M1 8
R_h_M1_7_2 700_1200_M1 800_1200_M1 8
R_h_M1_8_2 800_1200_M1 900_1200_M1 8
R_h_M1_0_3 0_1300_M1 100_1300_M1 8
R_h_M1_1_3 100_1300_M1 200_1300_M1 8
R_h_M1_2_3 200_1300_M1 300_1300_M1 8
R_h_M1_3_3 300_1300_M1 400_1300_M1 8
R_h_M1_4_3 400_1300_M1 500_1300_M1 8
R_h_M1_5_3 500_1300_M1 600_1300_M1 8
R_h_M1_6_3 600_1300_M1 700_1300_M1 8
R_h_M1_7_3 700_1300_M1 800_1300_M1 8
R_h_M1_8_3 800_1300_M1 900_1300_M1 8
R_h_M1_0_4 0_1400_M1 100_1400_M1 8
R_h_M1_1_4 100_1400_M1 200_1400_M1 8
R_h_M1_2_4 200_1400_M1 300_1400_M1 8
R_h_M1_3_4 300_1400_M1 400_1400_M1 8
R_h_M1_4_4 400_1400_M1 500_1400_M1 8
R_h_M1_5_4 500_1400_M1 600_1400_M1 8
R_h_M1_6_4 600_1400_M1 700_1400_M1 8
R_h_M1_7_4 700_1400_M1 800_1400_M1 8
R_h_M1_8_4 800_1400_M1 900_1400_M1 8
R_h_M1_0_5 0_1500_M1 100_1500_M1 8
R_h_M1_1_5 100_1500_M1 200_1500_M1 8
R_h_M1_2_5 200_1500_M1 300_1500_M1 8
R_h_M1_3_5 300_1500_M1 400_1500_M1 8
R_h_M1_4_5 400_1500_M1 500_1500_M1 8
R_h_M1_5_5 500_1500_M1 600_1500_M1 8
R_h_M1_6_5 600_1500_M1 700_1500_M1 8
R_h_M1_7_5 700_1500_M1 800_1500_M1 8
R_h_M1_8_5 800_1500_M1 900_1500_M1 8
R_h_M1_0_6 0_1600_M1 100_1600_M1 8
R_h_M1_1_6 100_1600_M1 200_1600_M1 8
R_h_M1_2_6 200_1600_M1 300_1600_M1 8
R_h_M1_3_6 300_1600_M1 400_1600_M1 8
R_h_M1_4_6 400_1600_M1 500_1600_M1 8
R_h_M1_5_6 500_1600_M1 600_1600_M1 8
R_h_M1_6_6 600_1600_M1 700_1600_M1 8
R_h_M1_7_6 700_1600_M1 800_1600_M1 8
R_h_M1_8_6 800_1600_M1 900_1600_M1 8
R_h_M1_0_7 0_1700_M1 100_1700_M1 8
R_h_M1_1_7 100_1700_M1 200_1700_M1 8
R_h_M1_2_7 200_1700_M1 300_1700_M1 8
R_h_M1_3_7 300_1700_M1 400_1700_M1 8
R_h_M1_4_7 400_1700_M1 500_1700_M1 8
R_h_M1_5_7 500_1700_M1 600_1700_M1 8
R_h_M1_6_7 600_1700_M1 700_1700_M1 8
R_h_M1_7_7 700_1700_M1 800_1700_M1 8
R_h_M1_8_7 800_1700_M1 900_1700_M1 8
R_h_M1_0_8 0_1800_M1 100_1800_M1 8
R_h_M1_1_8 100_1800_M1 200_1800_M1 8
R_h_M1_2_8 200_1800_M1 300_1800_M1 8
R_h_M1_3_8 300_1800_M1 400_1800_M1 8
R_h_M1_4_8 400_1800_M1 500_1800_M1 8
R_h_M1_5_8 500_1800_M1 600_1800_M1 8
R_h_M1_6_8 600_1800_M1 700_1800_M1 8
R_h_M1_7_8 700_1800_M1 800_1800_M1 8
R_h_M1_8_8 800_1800_M1 900_1800_M1 8
R_h_M1_0_9 0_1900_M1 100_1900_M1 8
R_h_M1_1_9 100_1900_M1 200_1900_M1 8
R_h_M1_2_9 200_1900_M1 300_1900_M1 8
R_h_M1_3_9 300_1900_M1 400_1900_M1 8
R_h_M1_4_9 400_1900_M1 500_1900_M1 8
R_h_M1_5_9 500_1900_M1 600_1900_M1 8
R_h_M1_6_9 600_1900_M1 700_1900_M1 8
R_h_M1_7_9 700_1900_M1 800_1900_M1 8
R_h_M1_8_9 800_1900_M1 900_1900_M1 8
* Vertical resistors (R=10 Ohm)
R_v_M1_0_0 0_1000_M1 0_1100_M1 10
R_v_M1_1_0 100_1000_M1 100_1100_M1 10
R_v_M1_2_0 200_1000_M1 200_1100_M1 10
R_v_M1_3_0 300_1000_M1 300_1100_M1 10
R_v_M1_4_0 400_1000_M1 400_1100_M1 10
R_v_M1_5_0 500_1000_M1 500_1100_M1 10
R_v_M1_6_0 600_1000_M1 600_1100_M1 10
R_v_M1_7_0 700_1000_M1 700_1100_M1 10
R_v_M1_8_0 800_1000_M1 800_1100_M1 10
R_v_M1_9_0 900_1000_M1 900_1100_M1 10
R_v_M1_0_1 0_1100_M1 0_1200_M1 10
R_v_M1_1_1 100_1100_M1 100_1200_M1 10
R_v_M1_2_1 200_1100_M1 200_1200_M1 10
R_v_M1_3_1 300_1100_M1 300_1200_M1 10
R_v_M1_4_1 400_1100_M1 400_1200_M1 10
R_v_M1_5_1 500_1100_M1 500_1200_M1 10
R_v_M1_6_1 600_1100_M1 600_1200_M1 10
R_v_M1_7_1 700_1100_M1 700_1200_M1 10
R_v_M1_8_1 800_1100_M1 800_1200_M1 10
R_v_M1_9_1 900_1100_M1 900_1200_M1 10
R_v_M1_0_2 0_1200_M1 0_1300_M1 10
R_v_M1_1_2 100_1200_M1 100_1300_M1 10
R_v_M1_2_2 200_1200_M1 200_1300_M1 10
R_v_M1_3_2 300_1200_M1 300_1300_M1 10
R_v_M1_4_2 400_1200_M1 400_1300_M1 10
R_v_M1_5_2 500_1200_M1 500_1300_M1 10
R_v_M1_6_2 600_1200_M1 600_1300_M1 10
R_v_M1_7_2 700_1200_M1 700_1300_M1 10
R_v_M1_8_2 800_1200_M1 800_1300_M1 10
R_v_M1_9_2 900_1200_M1 900_1300_M1 10
R_v_M1_0_3 0_1300_M1 0_1400_M1 10
R_v_M1_1_3 100_1300_M1 100_1400_M1 10
R_v_M1_2_3 200_1300_M1 200_1400_M1 10
R_v_M1_3_3 300_1300_M1 300_1400_M1 10
R_v_M1_4_3 400_1300_M1 400_1400_M1 10
R_v_M1_5_3 500_1300_M1 500_1400_M1 10
R_v_M1_6_3 600_1300_M1 600_1400_M1 10
R_v_M1_7_3 700_1300_M1 700_1400_M1 10
R_v_M1_8_3 800_1300_M1 800_1400_M1 10
R_v_M1_9_3 900_1300_M1 900_1400_M1 10
R_v_M1_0_4 0_1400_M1 0_1500_M1 10
R_v_M1_1_4 100_1400_M1 100_1500_M1 10
R_v_M1_2_4 200_1400_M1 200_1500_M1 10
R_v_M1_3_4 300_1400_M1 300_1500_M1 10
R_v_M1_4_4 400_1400_M1 400_1500_M1 10
R_v_M1_5_4 500_1400_M1 500_1500_M1 10
R_v_M1_6_4 600_1400_M1 600_1500_M1 10
R_v_M1_7_4 700_1400_M1 700_1500_M1 10
R_v_M1_8_4 800_1400_M1 800_1500_M1 10
R_v_M1_9_4 900_1400_M1 900_1500_M1 10
R_v_M1_0_5 0_1500_M1 0_1600_M1 10
R_v_M1_1_5 100_1500_M1 100_1600_M1 10
R_v_M1_2_5 200_1500_M1 200_1600_M1 10
R_v_M1_3_5 300_1500_M1 300_1600_M1 10
R_v_M1_4_5 400_1500_M1 400_1600_M1 10
R_v_M1_5_5 500_1500_M1 500_1600_M1 10
R_v_M1_6_5 600_1500_M1 600_1600_M1 10
R_v_M1_7_5 700_1500_M1 700_1600_M1 10
R_v_M1_8_5 800_1500_M1 800_1600_M1 10
R_v_M1_9_5 900_1500_M1 900_1600_M1 10
R_v_M1_0_6 0_1600_M1 0_1700_M1 10
R_v_M1_1_6 100_1600_M1 100_1700_M1 10
R_v_M1_2_6 200_1600_M1 200_1700_M1 10
R_v_M1_3_6 300_1600_M1 300_1700_M1 10
R_v_M1_4_6 400_1600_M1 400_1700_M1 10
R_v_M1_5_6 500_1600_M1 500_1700_M1 10
R_v_M1_6_6 600_1600_M1 600_1700_M1 10
R_v_M1_7_6 700_1600_M1 700_1700_M1 10
R_v_M1_8_6 800_1600_M1 800_1700_M1 10
R_v_M1_9_6 900_1600_M1 900_1700_M1 10
R_v_M1_0_7 0_1700_M1 0_1800_M1 10
R_v_M1_1_7 100_1700_M1 100_1800_M1 10
R_v_M1_2_7 200_1700_M1 200_1800_M1 10
R_v_M1_3_7 300_1700_M1 300_1800_M1 10
R_v_M1_4_7 400_1700_M1 400_1800_M1 10
R_v_M1_5_7 500_1700_M1 500_1800_M1 10
R_v_M1_6_7 600_1700_M1 600_1800_M1 10
R_v_M1_7_7 700_1700_M1 700_1800_M1 10
R_v_M1_8_7 800_1700_M1 800_1800_M1 10
R_v_M1_9_7 900_1700_M1 900_1800_M1 10
R_v_M1_0_8 0_1800_M1 0_1900_M1 10
R_v_M1_1_8 100_1800_M1 100_1900_M1 10
R_v_M1_2_8 200_1800_M1 200_1900_M1 10
R_v_M1_3_8 300_1800_M1 300_1900_M1 10
R_v_M1_4_8 400_1800_M1 400_1900_M1 10
R_v_M1_5_8 500_1800_M1 500_1900_M1 10
R_v_M1_6_8 600_1800_M1 600_1900_M1 10
R_v_M1_7_8 700_1800_M1 700_1900_M1 10
R_v_M1_8_8 800_1800_M1 800_1900_M1 10
R_v_M1_9_8 900_1800_M1 900_1900_M1 10
* Ground capacitors (C=5.0 fF)
C_g_M1_0_0 0_1000_M1 0 5e-15
C_g_M1_1_0 100_1000_M1 0 5e-15
C_g_M1_2_0 200_1000_M1 0 5e-15
C_g_M1_3_0 300_1000_M1 0 5e-15
C_g_M1_4_0 400_1000_M1 0 5e-15
C_g_M1_5_0 500_1000_M1 0 5e-15
C_g_M1_6_0 600_1000_M1 0 5e-15
C_g_M1_7_0 700_1000_M1 0 5e-15
C_g_M1_8_0 800_1000_M1 0 5e-15
C_g_M1_9_0 900_1000_M1 0 5e-15
C_g_M1_0_1 0_1100_M1 0 5e-15
C_g_M1_1_1 100_1100_M1 0 5e-15
C_g_M1_2_1 200_1100_M1 0 5e-15
C_g_M1_3_1 300_1100_M1 0 5e-15
C_g_M1_4_1 400_1100_M1 0 5e-15
C_g_M1_5_1 500_1100_M1 0 5e-15
C_g_M1_6_1 600_1100_M1 0 5e-15
C_g_M1_7_1 700_1100_M1 0 5e-15
C_g_M1_8_1 800_1100_M1 0 5e-15
C_g_M1_9_1 900_1100_M1 0 5e-15
C_g_M1_0_2 0_1200_M1 0 5e-15
C_g_M1_1_2 100_1200_M1 0 5e-15
C_g_M1_2_2 200_1200_M1 0 5e-15
C_g_M1_3_2 300_1200_M1 0 5e-15
C_g_M1_4_2 400_1200_M1 0 5e-15
C_g_M1_5_2 500_1200_M1 0 5e-15
C_g_M1_6_2 600_1200_M1 0 5e-15
C_g_M1_7_2 700_1200_M1 0 5e-15
C_g_M1_8_2 800_1200_M1 0 5e-15
C_g_M1_9_2 900_1200_M1 0 5e-15
C_g_M1_0_3 0_1300_M1 0 5e-15
C_g_M1_1_3 100_1300_M1 0 5e-15
C_g_M1_2_3 200_1300_M1 0 5e-15
C_g_M1_3_3 300_1300_M1 0 5e-15
C_g_M1_4_3 400_1300_M1 0 5e-15
C_g_M1_5_3 500_1300_M1 0 5e-15
C_g_M1_6_3 600_1300_M1 0 5e-15
C_g_M1_7_3 700_1300_M1 0 5e-15
C_g_M1_8_3 800_1300_M1 0 5e-15
C_g_M1_9_3 900_1300_M1 0 5e-15
C_g_M1_0_4 0_1400_M1 0 5e-15
C_g_M1_1_4 100_1400_M1 0 5e-15
C_g_M1_2_4 200_1400_M1 0 5e-15
C_g_M1_3_4 300_1400_M1 0 5e-15
C_g_M1_4_4 400_1400_M1 0 5e-15
C_g_M1_5_4 500_1400_M1 0 5e-15
C_g_M1_6_4 600_1400_M1 0 5e-15
C_g_M1_7_4 700_1400_M1 0 5e-15
C_g_M1_8_4 800_1400_M1 0 5e-15
C_g_M1_9_4 900_1400_M1 0 5e-15
C_g_M1_0_5 0_1500_M1 0 5e-15
C_g_M1_1_5 100_1500_M1 0 5e-15
C_g_M1_2_5 200_1500_M1 0 5e-15
C_g_M1_3_5 300_1500_M1 0 5e-15
C_g_M1_4_5 400_1500_M1 0 5e-15
C_g_M1_5_5 500_1500_M1 0 5e-15
C_g_M1_6_5 600_1500_M1 0 5e-15
C_g_M1_7_5 700_1500_M1 0 5e-15
C_g_M1_8_5 800_1500_M1 0 5e-15
C_g_M1_9_5 900_1500_M1 0 5e-15
C_g_M1_0_6 0_1600_M1 0 5e-15
C_g_M1_1_6 100_1600_M1 0 5e-15
C_g_M1_2_6 200_1600_M1 0 5e-15
C_g_M1_3_6 300_1600_M1 0 5e-15
C_g_M1_4_6 400_1600_M1 0 5e-15
C_g_M1_5_6 500_1600_M1 0 5e-15
C_g_M1_6_6 600_1600_M1 0 5e-15
C_g_M1_7_6 700_1600_M1 0 5e-15
C_g_M1_8_6 800_1600_M1 0 5e-15
C_g_M1_9_6 900_1600_M1 0 5e-15
C_g_M1_0_7 0_1700_M1 0 5e-15
C_g_M1_1_7 100_1700_M1 0 5e-15
C_g_M1_2_7 200_1700_M1 0 5e-15
C_g_M1_3_7 300_1700_M1 0 5e-15
C_g_M1_4_7 400_1700_M1 0 5e-15
C_g_M1_5_7 500_1700_M1 0 5e-15
C_g_M1_6_7 600_1700_M1 0 5e-15
C_g_M1_7_7 700_1700_M1 0 5e-15
C_g_M1_8_7 800_1700_M1 0 5e-15
C_g_M1_9_7 900_1700_M1 0 5e-15
C_g_M1_0_8 0_1800_M1 0 5e-15
C_g_M1_1_8 100_1800_M1 0 5e-15
C_g_M1_2_8 200_1800_M1 0 5e-15
C_g_M1_3_8 300_1800_M1 0 5e-15
C_g_M1_4_8 400_1800_M1 0 5e-15
C_g_M1_5_8 500_1800_M1 0 5e-15
C_g_M1_6_8 600_1800_M1 0 5e-15
C_g_M1_7_8 700_1800_M1 0 5e-15
C_g_M1_8_8 800_1800_M1 0 5e-15
C_g_M1_9_8 900_1800_M1 0 5e-15
C_g_M1_0_9 0_1900_M1 0 5e-15
C_g_M1_1_9 100_1900_M1 0 5e-15
C_g_M1_2_9 200_1900_M1 0 5e-15
C_g_M1_3_9 300_1900_M1 0 5e-15
C_g_M1_4_9 400_1900_M1 0 5e-15
C_g_M1_5_9 500_1900_M1 0 5e-15
C_g_M1_6_9 600_1900_M1 0 5e-15
C_g_M1_7_9 700_1900_M1 0 5e-15
C_g_M1_8_9 800_1900_M1 0 5e-15
C_g_M1_9_9 900_1900_M1 0 5e-15
* Coupling capacitors (C=1.0 fF)
C_coup_M1_0_0 0_1000_M1 100_1000_M1 1e-15
C_coup_M1_2_0 200_1000_M1 300_1000_M1 1e-15
C_coup_M1_4_0 400_1000_M1 500_1000_M1 1e-15
C_coup_M1_6_0 600_1000_M1 700_1000_M1 1e-15
C_coup_M1_8_0 800_1000_M1 900_1000_M1 1e-15
C_coup_M1_0_1 0_1100_M1 100_1100_M1 1e-15
C_coup_M1_2_1 200_1100_M1 300_1100_M1 1e-15
C_coup_M1_4_1 400_1100_M1 500_1100_M1 1e-15
C_coup_M1_6_1 600_1100_M1 700_1100_M1 1e-15
C_coup_M1_8_1 800_1100_M1 900_1100_M1 1e-15
C_coup_M1_0_2 0_1200_M1 100_1200_M1 1e-15
C_coup_M1_2_2 200_1200_M1 300_1200_M1 1e-15
C_coup_M1_4_2 400_1200_M1 500_1200_M1 1e-15
C_coup_M1_6_2 600_1200_M1 700_1200_M1 1e-15
C_coup_M1_8_2 800_1200_M1 900_1200_M1 1e-15
C_coup_M1_0_3 0_1300_M1 100_1300_M1 1e-15
C_coup_M1_2_3 200_1300_M1 300_1300_M1 1e-15
C_coup_M1_4_3 400_1300_M1 500_1300_M1 1e-15
C_coup_M1_6_3 600_1300_M1 700_1300_M1 1e-15
C_coup_M1_8_3 800_1300_M1 900_1300_M1 1e-15
C_coup_M1_0_4 0_1400_M1 100_1400_M1 1e-15
C_coup_M1_2_4 200_1400_M1 300_1400_M1 1e-15
C_coup_M1_4_4 400_1400_M1 500_1400_M1 1e-15
C_coup_M1_6_4 600_1400_M1 700_1400_M1 1e-15
C_coup_M1_8_4 800_1400_M1 900_1400_M1 1e-15
C_coup_M1_0_5 0_1500_M1 100_1500_M1 1e-15
C_coup_M1_2_5 200_1500_M1 300_1500_M1 1e-15
C_coup_M1_4_5 400_1500_M1 500_1500_M1 1e-15
C_coup_M1_6_5 600_1500_M1 700_1500_M1 1e-15
C_coup_M1_8_5 800_1500_M1 900_1500_M1 1e-15
C_coup_M1_0_6 0_1600_M1 100_1600_M1 1e-15
C_coup_M1_2_6 200_1600_M1 300_1600_M1 1e-15
C_coup_M1_4_6 400_1600_M1 500_1600_M1 1e-15
C_coup_M1_6_6 600_1600_M1 700_1600_M1 1e-15
C_coup_M1_8_6 800_1600_M1 900_1600_M1 1e-15
C_coup_M1_0_7 0_1700_M1 100_1700_M1 1e-15
C_coup_M1_2_7 200_1700_M1 300_1700_M1 1e-15
C_coup_M1_4_7 400_1700_M1 500_1700_M1 1e-15
C_coup_M1_6_7 600_1700_M1 700_1700_M1 1e-15
C_coup_M1_8_7 800_1700_M1 900_1700_M1 1e-15
C_coup_M1_0_8 0_1800_M1 100_1800_M1 1e-15
C_coup_M1_2_8 200_1800_M1 300_1800_M1 1e-15
C_coup_M1_4_8 400_1800_M1 500_1800_M1 1e-15
C_coup_M1_6_8 600_1800_M1 700_1800_M1 1e-15
C_coup_M1_8_8 800_1800_M1 900_1800_M1 1e-15
C_coup_M1_0_9 0_1900_M1 100_1900_M1 1e-15
C_coup_M1_2_9 200_1900_M1 300_1900_M1 1e-15
C_coup_M1_4_9 400_1900_M1 500_1900_M1 1e-15
C_coup_M1_6_9 600_1900_M1 700_1900_M1 1e-15
C_coup_M1_8_9 800_1900_M1 900_1900_M1 1e-15

* ========== Layer M2 ==========
* Horizontal resistors (R=5 Ohm)
R_h_M2_0_0 0_1000_M2 100_1000_M2 5
R_h_M2_1_0 100_1000_M2 200_1000_M2 5
R_h_M2_2_0 200_1000_M2 300_1000_M2 5
R_h_M2_3_0 300_1000_M2 400_1000_M2 5
R_h_M2_4_0 400_1000_M2 500_1000_M2 5
R_h_M2_5_0 500_1000_M2 600_1000_M2 5
R_h_M2_6_0 600_1000_M2 700_1000_M2 5
R_h_M2_7_0 700_1000_M2 800_1000_M2 5
R_h_M2_8_0 800_1000_M2 900_1000_M2 5
R_h_M2_0_1 0_1100_M2 100_1100_M2 5
R_h_M2_1_1 100_1100_M2 200_1100_M2 5
R_h_M2_2_1 200_1100_M2 300_1100_M2 5
R_h_M2_3_1 300_1100_M2 400_1100_M2 5
R_h_M2_4_1 400_1100_M2 500_1100_M2 5
R_h_M2_5_1 500_1100_M2 600_1100_M2 5
R_h_M2_6_1 600_1100_M2 700_1100_M2 5
R_h_M2_7_1 700_1100_M2 800_1100_M2 5
R_h_M2_8_1 800_1100_M2 900_1100_M2 5
R_h_M2_0_2 0_1200_M2 100_1200_M2 5
R_h_M2_1_2 100_1200_M2 200_1200_M2 5
R_h_M2_2_2 200_1200_M2 300_1200_M2 5
R_h_M2_3_2 300_1200_M2 400_1200_M2 5
R_h_M2_4_2 400_1200_M2 500_1200_M2 5
R_h_M2_5_2 500_1200_M2 600_1200_M2 5
R_h_M2_6_2 600_1200_M2 700_1200_M2 5
R_h_M2_7_2 700_1200_M2 800_1200_M2 5
R_h_M2_8_2 800_1200_M2 900_1200_M2 5
R_h_M2_0_3 0_1300_M2 100_1300_M2 5
R_h_M2_1_3 100_1300_M2 200_1300_M2 5
R_h_M2_2_3 200_1300_M2 300_1300_M2 5
R_h_M2_3_3 300_1300_M2 400_1300_M2 5
R_h_M2_4_3 400_1300_M2 500_1300_M2 5
R_h_M2_5_3 500_1300_M2 600_1300_M2 5
R_h_M2_6_3 600_1300_M2 700_1300_M2 5
R_h_M2_7_3 700_1300_M2 800_1300_M2 5
R_h_M2_8_3 800_1300_M2 900_1300_M2 5
R_h_M2_0_4 0_1400_M2 100_1400_M2 5
R_h_M2_1_4 100_1400_M2 200_1400_M2 5
R_h_M2_2_4 200_1400_M2 300_1400_M2 5
R_h_M2_3_4 300_1400_M2 400_1400_M2 5
R_h_M2_4_4 400_1400_M2 500_1400_M2 5
R_h_M2_5_4 500_1400_M2 600_1400_M2 5
R_h_M2_6_4 600_1400_M2 700_1400_M2 5
R_h_M2_7_4 700_1400_M2 800_1400_M2 5
R_h_M2_8_4 800_1400_M2 900_1400_M2 5
R_h_M2_0_5 0_1500_M2 100_1500_M2 5
R_h_M2_1_5 100_1500_M2 200_1500_M2 5
R_h_M2_2_5 200_1500_M2 300_1500_M2 5
R_h_M2_3_5 300_1500_M2 400_1500_M2 5
R_h_M2_4_5 400_1500_M2 500_1500_M2 5
R_h_M2_5_5 500_1500_M2 600_1500_M2 5
R_h_M2_6_5 600_1500_M2 700_1500_M2 5
R_h_M2_7_5 700_1500_M2 800_1500_M2 5
R_h_M2_8_5 800_1500_M2 900_1500_M2 5
R_h_M2_0_6 0_1600_M2 100_1600_M2 5
R_h_M2_1_6 100_1600_M2 200_1600_M2 5
R_h_M2_2_6 200_1600_M2 300_1600_M2 5
R_h_M2_3_6 300_1600_M2 400_1600_M2 5
R_h_M2_4_6 400_1600_M2 500_1600_M2 5
R_h_M2_5_6 500_1600_M2 600_1600_M2 5
R_h_M2_6_6 600_1600_M2 700_1600_M2 5
R_h_M2_7_6 700_1600_M2 800_1600_M2 5
R_h_M2_8_6 800_1600_M2 900_1600_M2 5
R_h_M2_0_7 0_1700_M2 100_1700_M2 5
R_h_M2_1_7 100_1700_M2 200_1700_M2 5
R_h_M2_2_7 200_1700_M2 300_1700_M2 5
R_h_M2_3_7 300_1700_M2 400_1700_M2 5
R_h_M2_4_7 400_1700_M2 500_1700_M2 5
R_h_M2_5_7 500_1700_M2 600_1700_M2 5
R_h_M2_6_7 600_1700_M2 700_1700_M2 5
R_h_M2_7_7 700_1700_M2 800_1700_M2 5
R_h_M2_8_7 800_1700_M2 900_1700_M2 5
R_h_M2_0_8 0_1800_M2 100_1800_M2 5
R_h_M2_1_8 100_1800_M2 200_1800_M2 5
R_h_M2_2_8 200_1800_M2 300_1800_M2 5
R_h_M2_3_8 300_1800_M2 400_1800_M2 5
R_h_M2_4_8 400_1800_M2 500_1800_M2 5
R_h_M2_5_8 500_1800_M2 600_1800_M2 5
R_h_M2_6_8 600_1800_M2 700_1800_M2 5
R_h_M2_7_8 700_1800_M2 800_1800_M2 5
R_h_M2_8_8 800_1800_M2 900_1800_M2 5
R_h_M2_0_9 0_1900_M2 100_1900_M2 5
R_h_M2_1_9 100_1900_M2 200_1900_M2 5
R_h_M2_2_9 200_1900_M2 300_1900_M2 5
R_h_M2_3_9 300_1900_M2 400_1900_M2 5
R_h_M2_4_9 400_1900_M2 500_1900_M2 5
R_h_M2_5_9 500_1900_M2 600_1900_M2 5
R_h_M2_6_9 600_1900_M2 700_1900_M2 5
R_h_M2_7_9 700_1900_M2 800_1900_M2 5
R_h_M2_8_9 800_1900_M2 900_1900_M2 5
* Vertical resistors (R=6 Ohm)
R_v_M2_0_0 0_1000_M2 0_1100_M2 6
R_v_M2_1_0 100_1000_M2 100_1100_M2 6
R_v_M2_2_0 200_1000_M2 200_1100_M2 6
R_v_M2_3_0 300_1000_M2 300_1100_M2 6
R_v_M2_4_0 400_1000_M2 400_1100_M2 6
R_v_M2_5_0 500_1000_M2 500_1100_M2 6
R_v_M2_6_0 600_1000_M2 600_1100_M2 6
R_v_M2_7_0 700_1000_M2 700_1100_M2 6
R_v_M2_8_0 800_1000_M2 800_1100_M2 6
R_v_M2_9_0 900_1000_M2 900_1100_M2 6
R_v_M2_0_1 0_1100_M2 0_1200_M2 6
R_v_M2_1_1 100_1100_M2 100_1200_M2 6
R_v_M2_2_1 200_1100_M2 200_1200_M2 6
R_v_M2_3_1 300_1100_M2 300_1200_M2 6
R_v_M2_4_1 400_1100_M2 400_1200_M2 6
R_v_M2_5_1 500_1100_M2 500_1200_M2 6
R_v_M2_6_1 600_1100_M2 600_1200_M2 6
R_v_M2_7_1 700_1100_M2 700_1200_M2 6
R_v_M2_8_1 800_1100_M2 800_1200_M2 6
R_v_M2_9_1 900_1100_M2 900_1200_M2 6
R_v_M2_0_2 0_1200_M2 0_1300_M2 6
R_v_M2_1_2 100_1200_M2 100_1300_M2 6
R_v_M2_2_2 200_1200_M2 200_1300_M2 6
R_v_M2_3_2 300_1200_M2 300_1300_M2 6
R_v_M2_4_2 400_1200_M2 400_1300_M2 6
R_v_M2_5_2 500_1200_M2 500_1300_M2 6
R_v_M2_6_2 600_1200_M2 600_1300_M2 6
R_v_M2_7_2 700_1200_M2 700_1300_M2 6
R_v_M2_8_2 800_1200_M2 800_1300_M2 6
R_v_M2_9_2 900_1200_M2 900_1300_M2 6
R_v_M2_0_3 0_1300_M2 0_1400_M2 6
R_v_M2_1_3 100_1300_M2 100_1400_M2 6
R_v_M2_2_3 200_1300_M2 200_1400_M2 6
R_v_M2_3_3 300_1300_M2 300_1400_M2 6
R_v_M2_4_3 400_1300_M2 400_1400_M2 6
R_v_M2_5_3 500_1300_M2 500_1400_M2 6
R_v_M2_6_3 600_1300_M2 600_1400_M2 6
R_v_M2_7_3 700_1300_M2 700_1400_M2 6
R_v_M2_8_3 800_1300_M2 800_1400_M2 6
R_v_M2_9_3 900_1300_M2 900_1400_M2 6
R_v_M2_0_4 0_1400_M2 0_1500_M2 6
R_v_M2_1_4 100_1400_M2 100_1500_M2 6
R_v_M2_2_4 200_1400_M2 200_1500_M2 6
R_v_M2_3_4 300_1400_M2 300_1500_M2 6
R_v_M2_4_4 400_1400_M2 400_1500_M2 6
R_v_M2_5_4 500_1400_M2 500_1500_M2 6
R_v_M2_6_4 600_1400_M2 600_1500_M2 6
R_v_M2_7_4 700_1400_M2 700_1500_M2 6
R_v_M2_8_4 800_1400_M2 800_1500_M2 6
R_v_M2_9_4 900_1400_M2 900_1500_M2 6
R_v_M2_0_5 0_1500_M2 0_1600_M2 6
R_v_M2_1_5 100_1500_M2 100_1600_M2 6
R_v_M2_2_5 200_1500_M2 200_1600_M2 6
R_v_M2_3_5 300_1500_M2 300_1600_M2 6
R_v_M2_4_5 400_1500_M2 400_1600_M2 6
R_v_M2_5_5 500_1500_M2 500_1600_M2 6
R_v_M2_6_5 600_1500_M2 600_1600_M2 6
R_v_M2_7_5 700_1500_M2 700_1600_M2 6
R_v_M2_8_5 800_1500_M2 800_1600_M2 6
R_v_M2_9_5 900_1500_M2 900_1600_M2 6
R_v_M2_0_6 0_1600_M2 0_1700_M2 6
R_v_M2_1_6 100_1600_M2 100_1700_M2 6
R_v_M2_2_6 200_1600_M2 200_1700_M2 6
R_v_M2_3_6 300_1600_M2 300_1700_M2 6
R_v_M2_4_6 400_1600_M2 400_1700_M2 6
R_v_M2_5_6 500_1600_M2 500_1700_M2 6
R_v_M2_6_6 600_1600_M2 600_1700_M2 6
R_v_M2_7_6 700_1600_M2 700_1700_M2 6
R_v_M2_8_6 800_1600_M2 800_1700_M2 6
R_v_M2_9_6 900_1600_M2 900_1700_M2 6
R_v_M2_0_7 0_1700_M2 0_1800_M2 6
R_v_M2_1_7 100_1700_M2 100_1800_M2 6
R_v_M2_2_7 200_1700_M2 200_1800_M2 6
R_v_M2_3_7 300_1700_M2 300_1800_M2 6
R_v_M2_4_7 400_1700_M2 400_1800_M2 6
R_v_M2_5_7 500_1700_M2 500_1800_M2 6
R_v_M2_6_7 600_1700_M2 600_1800_M2 6
R_v_M2_7_7 700_1700_M2 700_1800_M2 6
R_v_M2_8_7 800_1700_M2 800_1800_M2 6
R_v_M2_9_7 900_1700_M2 900_1800_M2 6
R_v_M2_0_8 0_1800_M2 0_1900_M2 6
R_v_M2_1_8 100_1800_M2 100_1900_M2 6
R_v_M2_2_8 200_1800_M2 200_1900_M2 6
R_v_M2_3_8 300_1800_M2 300_1900_M2 6
R_v_M2_4_8 400_1800_M2 400_1900_M2 6
R_v_M2_5_8 500_1800_M2 500_1900_M2 6
R_v_M2_6_8 600_1800_M2 600_1900_M2 6
R_v_M2_7_8 700_1800_M2 700_1900_M2 6
R_v_M2_8_8 800_1800_M2 800_1900_M2 6
R_v_M2_9_8 900_1800_M2 900_1900_M2 6
* Ground capacitors (C=3.0 fF)
C_g_M2_0_0 0_1000_M2 0 3e-15
C_g_M2_1_0 100_1000_M2 0 3e-15
C_g_M2_2_0 200_1000_M2 0 3e-15
C_g_M2_3_0 300_1000_M2 0 3e-15
C_g_M2_4_0 400_1000_M2 0 3e-15
C_g_M2_5_0 500_1000_M2 0 3e-15
C_g_M2_6_0 600_1000_M2 0 3e-15
C_g_M2_7_0 700_1000_M2 0 3e-15
C_g_M2_8_0 800_1000_M2 0 3e-15
C_g_M2_9_0 900_1000_M2 0 3e-15
C_g_M2_0_1 0_1100_M2 0 3e-15
C_g_M2_1_1 100_1100_M2 0 3e-15
C_g_M2_2_1 200_1100_M2 0 3e-15
C_g_M2_3_1 300_1100_M2 0 3e-15
C_g_M2_4_1 400_1100_M2 0 3e-15
C_g_M2_5_1 500_1100_M2 0 3e-15
C_g_M2_6_1 600_1100_M2 0 3e-15
C_g_M2_7_1 700_1100_M2 0 3e-15
C_g_M2_8_1 800_1100_M2 0 3e-15
C_g_M2_9_1 900_1100_M2 0 3e-15
C_g_M2_0_2 0_1200_M2 0 3e-15
C_g_M2_1_2 100_1200_M2 0 3e-15
C_g_M2_2_2 200_1200_M2 0 3e-15
C_g_M2_3_2 300_1200_M2 0 3e-15
C_g_M2_4_2 400_1200_M2 0 3e-15
C_g_M2_5_2 500_1200_M2 0 3e-15
C_g_M2_6_2 600_1200_M2 0 3e-15
C_g_M2_7_2 700_1200_M2 0 3e-15
C_g_M2_8_2 800_1200_M2 0 3e-15
C_g_M2_9_2 900_1200_M2 0 3e-15
C_g_M2_0_3 0_1300_M2 0 3e-15
C_g_M2_1_3 100_1300_M2 0 3e-15
C_g_M2_2_3 200_1300_M2 0 3e-15
C_g_M2_3_3 300_1300_M2 0 3e-15
C_g_M2_4_3 400_1300_M2 0 3e-15
C_g_M2_5_3 500_1300_M2 0 3e-15
C_g_M2_6_3 600_1300_M2 0 3e-15
C_g_M2_7_3 700_1300_M2 0 3e-15
C_g_M2_8_3 800_1300_M2 0 3e-15
C_g_M2_9_3 900_1300_M2 0 3e-15
C_g_M2_0_4 0_1400_M2 0 3e-15
C_g_M2_1_4 100_1400_M2 0 3e-15
C_g_M2_2_4 200_1400_M2 0 3e-15
C_g_M2_3_4 300_1400_M2 0 3e-15
C_g_M2_4_4 400_1400_M2 0 3e-15
C_g_M2_5_4 500_1400_M2 0 3e-15
C_g_M2_6_4 600_1400_M2 0 3e-15
C_g_M2_7_4 700_1400_M2 0 3e-15
C_g_M2_8_4 800_1400_M2 0 3e-15
C_g_M2_9_4 900_1400_M2 0 3e-15
C_g_M2_0_5 0_1500_M2 0 3e-15
C_g_M2_1_5 100_1500_M2 0 3e-15
C_g_M2_2_5 200_1500_M2 0 3e-15
C_g_M2_3_5 300_1500_M2 0 3e-15
C_g_M2_4_5 400_1500_M2 0 3e-15
C_g_M2_5_5 500_1500_M2 0 3e-15
C_g_M2_6_5 600_1500_M2 0 3e-15
C_g_M2_7_5 700_1500_M2 0 3e-15
C_g_M2_8_5 800_1500_M2 0 3e-15
C_g_M2_9_5 900_1500_M2 0 3e-15
C_g_M2_0_6 0_1600_M2 0 3e-15
C_g_M2_1_6 100_1600_M2 0 3e-15
C_g_M2_2_6 200_1600_M2 0 3e-15
C_g_M2_3_6 300_1600_M2 0 3e-15
C_g_M2_4_6 400_1600_M2 0 3e-15
C_g_M2_5_6 500_1600_M2 0 3e-15
C_g_M2_6_6 600_1600_M2 0 3e-15
C_g_M2_7_6 700_1600_M2 0 3e-15
C_g_M2_8_6 800_1600_M2 0 3e-15
C_g_M2_9_6 900_1600_M2 0 3e-15
C_g_M2_0_7 0_1700_M2 0 3e-15
C_g_M2_1_7 100_1700_M2 0 3e-15
C_g_M2_2_7 200_1700_M2 0 3e-15
C_g_M2_3_7 300_1700_M2 0 3e-15
C_g_M2_4_7 400_1700_M2 0 3e-15
C_g_M2_5_7 500_1700_M2 0 3e-15
C_g_M2_6_7 600_1700_M2 0 3e-15
C_g_M2_7_7 700_1700_M2 0 3e-15
C_g_M2_8_7 800_1700_M2 0 3e-15
C_g_M2_9_7 900_1700_M2 0 3e-15
C_g_M2_0_8 0_1800_M2 0 3e-15
C_g_M2_1_8 100_1800_M2 0 3e-15
C_g_M2_2_8 200_1800_M2 0 3e-15
C_g_M2_3_8 300_1800_M2 0 3e-15
C_g_M2_4_8 400_1800_M2 0 3e-15
C_g_M2_5_8 500_1800_M2 0 3e-15
C_g_M2_6_8 600_1800_M2 0 3e-15
C_g_M2_7_8 700_1800_M2 0 3e-15
C_g_M2_8_8 800_1800_M2 0 3e-15
C_g_M2_9_8 900_1800_M2 0 3e-15
C_g_M2_0_9 0_1900_M2 0 3e-15
C_g_M2_1_9 100_1900_M2 0 3e-15
C_g_M2_2_9 200_1900_M2 0 3e-15
C_g_M2_3_9 300_1900_M2 0 3e-15
C_g_M2_4_9 400_1900_M2 0 3e-15
C_g_M2_5_9 500_1900_M2 0 3e-15
C_g_M2_6_9 600_1900_M2 0 3e-15
C_g_M2_7_9 700_1900_M2 0 3e-15
C_g_M2_8_9 800_1900_M2 0 3e-15
C_g_M2_9_9 900_1900_M2 0 3e-15
* Coupling capacitors (C=1.0 fF)
C_coup_M2_0_0 0_1000_M2 100_1000_M2 1e-15
C_coup_M2_2_0 200_1000_M2 300_1000_M2 1e-15
C_coup_M2_4_0 400_1000_M2 500_1000_M2 1e-15
C_coup_M2_6_0 600_1000_M2 700_1000_M2 1e-15
C_coup_M2_8_0 800_1000_M2 900_1000_M2 1e-15
C_coup_M2_0_1 0_1100_M2 100_1100_M2 1e-15
C_coup_M2_2_1 200_1100_M2 300_1100_M2 1e-15
C_coup_M2_4_1 400_1100_M2 500_1100_M2 1e-15
C_coup_M2_6_1 600_1100_M2 700_1100_M2 1e-15
C_coup_M2_8_1 800_1100_M2 900_1100_M2 1e-15
C_coup_M2_0_2 0_1200_M2 100_1200_M2 1e-15
C_coup_M2_2_2 200_1200_M2 300_1200_M2 1e-15
C_coup_M2_4_2 400_1200_M2 500_1200_M2 1e-15
C_coup_M2_6_2 600_1200_M2 700_1200_M2 1e-15
C_coup_M2_8_2 800_1200_M2 900_1200_M2 1e-15
C_coup_M2_0_3 0_1300_M2 100_1300_M2 1e-15
C_coup_M2_2_3 200_1300_M2 300_1300_M2 1e-15
C_coup_M2_4_3 400_1300_M2 500_1300_M2 1e-15
C_coup_M2_6_3 600_1300_M2 700_1300_M2 1e-15
C_coup_M2_8_3 800_1300_M2 900_1300_M2 1e-15
C_coup_M2_0_4 0_1400_M2 100_1400_M2 1e-15
C_coup_M2_2_4 200_1400_M2 300_1400_M2 1e-15
C_coup_M2_4_4 400_1400_M2 500_1400_M2 1e-15
C_coup_M2_6_4 600_1400_M2 700_1400_M2 1e-15
C_coup_M2_8_4 800_1400_M2 900_1400_M2 1e-15
C_coup_M2_0_5 0_1500_M2 100_1500_M2 1e-15
C_coup_M2_2_5 200_1500_M2 300_1500_M2 1e-15
C_coup_M2_4_5 400_1500_M2 500_1500_M2 1e-15
C_coup_M2_6_5 600_1500_M2 700_1500_M2 1e-15
C_coup_M2_8_5 800_1500_M2 900_1500_M2 1e-15
C_coup_M2_0_6 0_1600_M2 100_1600_M2 1e-15
C_coup_M2_2_6 200_1600_M2 300_1600_M2 1e-15
C_coup_M2_4_6 400_1600_M2 500_1600_M2 1e-15
C_coup_M2_6_6 600_1600_M2 700_1600_M2 1e-15
C_coup_M2_8_6 800_1600_M2 900_1600_M2 1e-15
C_coup_M2_0_7 0_1700_M2 100_1700_M2 1e-15
C_coup_M2_2_7 200_1700_M2 300_1700_M2 1e-15
C_coup_M2_4_7 400_1700_M2 500_1700_M2 1e-15
C_coup_M2_6_7 600_1700_M2 700_1700_M2 1e-15
C_coup_M2_8_7 800_1700_M2 900_1700_M2 1e-15
C_coup_M2_0_8 0_1800_M2 100_1800_M2 1e-15
C_coup_M2_2_8 200_1800_M2 300_1800_M2 1e-15
C_coup_M2_4_8 400_1800_M2 500_1800_M2 1e-15
C_coup_M2_6_8 600_1800_M2 700_1800_M2 1e-15
C_coup_M2_8_8 800_1800_M2 900_1800_M2 1e-15
C_coup_M2_0_9 0_1900_M2 100_1900_M2 1e-15
C_coup_M2_2_9 200_1900_M2 300_1900_M2 1e-15
C_coup_M2_4_9 400_1900_M2 500_1900_M2 1e-15
C_coup_M2_6_9 600_1900_M2 700_1900_M2 1e-15
C_coup_M2_8_9 800_1900_M2 900_1900_M2 1e-15

* ========== Layer M3 ==========
* Horizontal resistors (R=3 Ohm)
R_h_M3_0_0 0_1000_M3 100_1000_M3 3
R_h_M3_1_0 100_1000_M3 200_1000_M3 3
R_h_M3_2_0 200_1000_M3 300_1000_M3 3
R_h_M3_3_0 300_1000_M3 400_1000_M3 3
R_h_M3_4_0 400_1000_M3 500_1000_M3 3
R_h_M3_5_0 500_1000_M3 600_1000_M3 3
R_h_M3_6_0 600_1000_M3 700_1000_M3 3
R_h_M3_7_0 700_1000_M3 800_1000_M3 3
R_h_M3_8_0 800_1000_M3 900_1000_M3 3
R_h_M3_0_1 0_1100_M3 100_1100_M3 3
R_h_M3_1_1 100_1100_M3 200_1100_M3 3
R_h_M3_2_1 200_1100_M3 300_1100_M3 3
R_h_M3_3_1 300_1100_M3 400_1100_M3 3
R_h_M3_4_1 400_1100_M3 500_1100_M3 3
R_h_M3_5_1 500_1100_M3 600_1100_M3 3
R_h_M3_6_1 600_1100_M3 700_1100_M3 3
R_h_M3_7_1 700_1100_M3 800_1100_M3 3
R_h_M3_8_1 800_1100_M3 900_1100_M3 3
R_h_M3_0_2 0_1200_M3 100_1200_M3 3
R_h_M3_1_2 100_1200_M3 200_1200_M3 3
R_h_M3_2_2 200_1200_M3 300_1200_M3 3
R_h_M3_3_2 300_1200_M3 400_1200_M3 3
R_h_M3_4_2 400_1200_M3 500_1200_M3 3
R_h_M3_5_2 500_1200_M3 600_1200_M3 3
R_h_M3_6_2 600_1200_M3 700_1200_M3 3
R_h_M3_7_2 700_1200_M3 800_1200_M3 3
R_h_M3_8_2 800_1200_M3 900_1200_M3 3
R_h_M3_0_3 0_1300_M3 100_1300_M3 3
R_h_M3_1_3 100_1300_M3 200_1300_M3 3
R_h_M3_2_3 200_1300_M3 300_1300_M3 3
R_h_M3_3_3 300_1300_M3 400_1300_M3 3
R_h_M3_4_3 400_1300_M3 500_1300_M3 3
R_h_M3_5_3 500_1300_M3 600_1300_M3 3
R_h_M3_6_3 600_1300_M3 700_1300_M3 3
R_h_M3_7_3 700_1300_M3 800_1300_M3 3
R_h_M3_8_3 800_1300_M3 900_1300_M3 3
R_h_M3_0_4 0_1400_M3 100_1400_M3 3
R_h_M3_1_4 100_1400_M3 200_1400_M3 3
R_h_M3_2_4 200_1400_M3 300_1400_M3 3
R_h_M3_3_4 300_1400_M3 400_1400_M3 3
R_h_M3_4_4 400_1400_M3 500_1400_M3 3
R_h_M3_5_4 500_1400_M3 600_1400_M3 3
R_h_M3_6_4 600_1400_M3 700_1400_M3 3
R_h_M3_7_4 700_1400_M3 800_1400_M3 3
R_h_M3_8_4 800_1400_M3 900_1400_M3 3
R_h_M3_0_5 0_1500_M3 100_1500_M3 3
R_h_M3_1_5 100_1500_M3 200_1500_M3 3
R_h_M3_2_5 200_1500_M3 300_1500_M3 3
R_h_M3_3_5 300_1500_M3 400_1500_M3 3
R_h_M3_4_5 400_1500_M3 500_1500_M3 3
R_h_M3_5_5 500_1500_M3 600_1500_M3 3
R_h_M3_6_5 600_1500_M3 700_1500_M3 3
R_h_M3_7_5 700_1500_M3 800_1500_M3 3
R_h_M3_8_5 800_1500_M3 900_1500_M3 3
R_h_M3_0_6 0_1600_M3 100_1600_M3 3
R_h_M3_1_6 100_1600_M3 200_1600_M3 3
R_h_M3_2_6 200_1600_M3 300_1600_M3 3
R_h_M3_3_6 300_1600_M3 400_1600_M3 3
R_h_M3_4_6 400_1600_M3 500_1600_M3 3
R_h_M3_5_6 500_1600_M3 600_1600_M3 3
R_h_M3_6_6 600_1600_M3 700_1600_M3 3
R_h_M3_7_6 700_1600_M3 800_1600_M3 3
R_h_M3_8_6 800_1600_M3 900_1600_M3 3
R_h_M3_0_7 0_1700_M3 100_1700_M3 3
R_h_M3_1_7 100_1700_M3 200_1700_M3 3
R_h_M3_2_7 200_1700_M3 300_1700_M3 3
R_h_M3_3_7 300_1700_M3 400_1700_M3 3
R_h_M3_4_7 400_1700_M3 500_1700_M3 3
R_h_M3_5_7 500_1700_M3 600_1700_M3 3
R_h_M3_6_7 600_1700_M3 700_1700_M3 3
R_h_M3_7_7 700_1700_M3 800_1700_M3 3
R_h_M3_8_7 800_1700_M3 900_1700_M3 3
R_h_M3_0_8 0_1800_M3 100_1800_M3 3
R_h_M3_1_8 100_1800_M3 200_1800_M3 3
R_h_M3_2_8 200_1800_M3 300_1800_M3 3
R_h_M3_3_8 300_1800_M3 400_1800_M3 3
R_h_M3_4_8 400_1800_M3 500_1800_M3 3
R_h_M3_5_8 500_1800_M3 600_1800_M3 3
R_h_M3_6_8 600_1800_M3 700_1800_M3 3
R_h_M3_7_8 700_1800_M3 800_1800_M3 3
R_h_M3_8_8 800_1800_M3 900_1800_M3 3
R_h_M3_0_9 0_1900_M3 100_1900_M3 3
R_h_M3_1_9 100_1900_M3 200_1900_M3 3
R_h_M3_2_9 200_1900_M3 300_1900_M3 3
R_h_M3_3_9 300_1900_M3 400_1900_M3 3
R_h_M3_4_9 400_1900_M3 500_1900_M3 3
R_h_M3_5_9 500_1900_M3 600_1900_M3 3
R_h_M3_6_9 600_1900_M3 700_1900_M3 3
R_h_M3_7_9 700_1900_M3 800_1900_M3 3
R_h_M3_8_9 800_1900_M3 900_1900_M3 3
* Vertical resistors (R=4 Ohm)
R_v_M3_0_0 0_1000_M3 0_1100_M3 4
R_v_M3_1_0 100_1000_M3 100_1100_M3 4
R_v_M3_2_0 200_1000_M3 200_1100_M3 4
R_v_M3_3_0 300_1000_M3 300_1100_M3 4
R_v_M3_4_0 400_1000_M3 400_1100_M3 4
R_v_M3_5_0 500_1000_M3 500_1100_M3 4
R_v_M3_6_0 600_1000_M3 600_1100_M3 4
R_v_M3_7_0 700_1000_M3 700_1100_M3 4
R_v_M3_8_0 800_1000_M3 800_1100_M3 4
R_v_M3_9_0 900_1000_M3 900_1100_M3 4
R_v_M3_0_1 0_1100_M3 0_1200_M3 4
R_v_M3_1_1 100_1100_M3 100_1200_M3 4
R_v_M3_2_1 200_1100_M3 200_1200_M3 4
R_v_M3_3_1 300_1100_M3 300_1200_M3 4
R_v_M3_4_1 400_1100_M3 400_1200_M3 4
R_v_M3_5_1 500_1100_M3 500_1200_M3 4
R_v_M3_6_1 600_1100_M3 600_1200_M3 4
R_v_M3_7_1 700_1100_M3 700_1200_M3 4
R_v_M3_8_1 800_1100_M3 800_1200_M3 4
R_v_M3_9_1 900_1100_M3 900_1200_M3 4
R_v_M3_0_2 0_1200_M3 0_1300_M3 4
R_v_M3_1_2 100_1200_M3 100_1300_M3 4
R_v_M3_2_2 200_1200_M3 200_1300_M3 4
R_v_M3_3_2 300_1200_M3 300_1300_M3 4
R_v_M3_4_2 400_1200_M3 400_1300_M3 4
R_v_M3_5_2 500_1200_M3 500_1300_M3 4
R_v_M3_6_2 600_1200_M3 600_1300_M3 4
R_v_M3_7_2 700_1200_M3 700_1300_M3 4
R_v_M3_8_2 800_1200_M3 800_1300_M3 4
R_v_M3_9_2 900_1200_M3 900_1300_M3 4
R_v_M3_0_3 0_1300_M3 0_1400_M3 4
R_v_M3_1_3 100_1300_M3 100_1400_M3 4
R_v_M3_2_3 200_1300_M3 200_1400_M3 4
R_v_M3_3_3 300_1300_M3 300_1400_M3 4
R_v_M3_4_3 400_1300_M3 400_1400_M3 4
R_v_M3_5_3 500_1300_M3 500_1400_M3 4
R_v_M3_6_3 600_1300_M3 600_1400_M3 4
R_v_M3_7_3 700_1300_M3 700_1400_M3 4
R_v_M3_8_3 800_1300_M3 800_1400_M3 4
R_v_M3_9_3 900_1300_M3 900_1400_M3 4
R_v_M3_0_4 0_1400_M3 0_1500_M3 4
R_v_M3_1_4 100_1400_M3 100_1500_M3 4
R_v_M3_2_4 200_1400_M3 200_1500_M3 4
R_v_M3_3_4 300_1400_M3 300_1500_M3 4
R_v_M3_4_4 400_1400_M3 400_1500_M3 4
R_v_M3_5_4 500_1400_M3 500_1500_M3 4
R_v_M3_6_4 600_1400_M3 600_1500_M3 4
R_v_M3_7_4 700_1400_M3 700_1500_M3 4
R_v_M3_8_4 800_1400_M3 800_1500_M3 4
R_v_M3_9_4 900_1400_M3 900_1500_M3 4
R_v_M3_0_5 0_1500_M3 0_1600_M3 4
R_v_M3_1_5 100_1500_M3 100_1600_M3 4
R_v_M3_2_5 200_1500_M3 200_1600_M3 4
R_v_M3_3_5 300_1500_M3 300_1600_M3 4
R_v_M3_4_5 400_1500_M3 400_1600_M3 4
R_v_M3_5_5 500_1500_M3 500_1600_M3 4
R_v_M3_6_5 600_1500_M3 600_1600_M3 4
R_v_M3_7_5 700_1500_M3 700_1600_M3 4
R_v_M3_8_5 800_1500_M3 800_1600_M3 4
R_v_M3_9_5 900_1500_M3 900_1600_M3 4
R_v_M3_0_6 0_1600_M3 0_1700_M3 4
R_v_M3_1_6 100_1600_M3 100_1700_M3 4
R_v_M3_2_6 200_1600_M3 200_1700_M3 4
R_v_M3_3_6 300_1600_M3 300_1700_M3 4
R_v_M3_4_6 400_1600_M3 400_1700_M3 4
R_v_M3_5_6 500_1600_M3 500_1700_M3 4
R_v_M3_6_6 600_1600_M3 600_1700_M3 4
R_v_M3_7_6 700_1600_M3 700_1700_M3 4
R_v_M3_8_6 800_1600_M3 800_1700_M3 4
R_v_M3_9_6 900_1600_M3 900_1700_M3 4
R_v_M3_0_7 0_1700_M3 0_1800_M3 4
R_v_M3_1_7 100_1700_M3 100_1800_M3 4
R_v_M3_2_7 200_1700_M3 200_1800_M3 4
R_v_M3_3_7 300_1700_M3 300_1800_M3 4
R_v_M3_4_7 400_1700_M3 400_1800_M3 4
R_v_M3_5_7 500_1700_M3 500_1800_M3 4
R_v_M3_6_7 600_1700_M3 600_1800_M3 4
R_v_M3_7_7 700_1700_M3 700_1800_M3 4
R_v_M3_8_7 800_1700_M3 800_1800_M3 4
R_v_M3_9_7 900_1700_M3 900_1800_M3 4
R_v_M3_0_8 0_1800_M3 0_1900_M3 4
R_v_M3_1_8 100_1800_M3 100_1900_M3 4
R_v_M3_2_8 200_1800_M3 200_1900_M3 4
R_v_M3_3_8 300_1800_M3 300_1900_M3 4
R_v_M3_4_8 400_1800_M3 400_1900_M3 4
R_v_M3_5_8 500_1800_M3 500_1900_M3 4
R_v_M3_6_8 600_1800_M3 600_1900_M3 4
R_v_M3_7_8 700_1800_M3 700_1900_M3 4
R_v_M3_8_8 800_1800_M3 800_1900_M3 4
R_v_M3_9_8 900_1800_M3 900_1900_M3 4
* Ground capacitors (C=2.0 fF)
C_g_M3_0_0 0_1000_M3 0 2e-15
C_g_M3_1_0 100_1000_M3 0 2e-15
C_g_M3_2_0 200_1000_M3 0 2e-15
C_g_M3_3_0 300_1000_M3 0 2e-15
C_g_M3_4_0 400_1000_M3 0 2e-15
C_g_M3_5_0 500_1000_M3 0 2e-15
C_g_M3_6_0 600_1000_M3 0 2e-15
C_g_M3_7_0 700_1000_M3 0 2e-15
C_g_M3_8_0 800_1000_M3 0 2e-15
C_g_M3_9_0 900_1000_M3 0 2e-15
C_g_M3_0_1 0_1100_M3 0 2e-15
C_g_M3_1_1 100_1100_M3 0 2e-15
C_g_M3_2_1 200_1100_M3 0 2e-15
C_g_M3_3_1 300_1100_M3 0 2e-15
C_g_M3_4_1 400_1100_M3 0 2e-15
C_g_M3_5_1 500_1100_M3 0 2e-15
C_g_M3_6_1 600_1100_M3 0 2e-15
C_g_M3_7_1 700_1100_M3 0 2e-15
C_g_M3_8_1 800_1100_M3 0 2e-15
C_g_M3_9_1 900_1100_M3 0 2e-15
C_g_M3_0_2 0_1200_M3 0 2e-15
C_g_M3_1_2 100_1200_M3 0 2e-15
C_g_M3_2_2 200_1200_M3 0 2e-15
C_g_M3_3_2 300_1200_M3 0 2e-15
C_g_M3_4_2 400_1200_M3 0 2e-15
C_g_M3_5_2 500_1200_M3 0 2e-15
C_g_M3_6_2 600_1200_M3 0 2e-15
C_g_M3_7_2 700_1200_M3 0 2e-15
C_g_M3_8_2 800_1200_M3 0 2e-15
C_g_M3_9_2 900_1200_M3 0 2e-15
C_g_M3_0_3 0_1300_M3 0 2e-15
C_g_M3_1_3 100_1300_M3 0 2e-15
C_g_M3_2_3 200_1300_M3 0 2e-15
C_g_M3_3_3 300_1300_M3 0 2e-15
C_g_M3_4_3 400_1300_M3 0 2e-15
C_g_M3_5_3 500_1300_M3 0 2e-15
C_g_M3_6_3 600_1300_M3 0 2e-15
C_g_M3_7_3 700_1300_M3 0 2e-15
C_g_M3_8_3 800_1300_M3 0 2e-15
C_g_M3_9_3 900_1300_M3 0 2e-15
C_g_M3_0_4 0_1400_M3 0 2e-15
C_g_M3_1_4 100_1400_M3 0 2e-15
C_g_M3_2_4 200_1400_M3 0 2e-15
C_g_M3_3_4 300_1400_M3 0 2e-15
C_g_M3_4_4 400_1400_M3 0 2e-15
C_g_M3_5_4 500_1400_M3 0 2e-15
C_g_M3_6_4 600_1400_M3 0 2e-15
C_g_M3_7_4 700_1400_M3 0 2e-15
C_g_M3_8_4 800_1400_M3 0 2e-15
C_g_M3_9_4 900_1400_M3 0 2e-15
C_g_M3_0_5 0_1500_M3 0 2e-15
C_g_M3_1_5 100_1500_M3 0 2e-15
C_g_M3_2_5 200_1500_M3 0 2e-15
C_g_M3_3_5 300_1500_M3 0 2e-15
C_g_M3_4_5 400_1500_M3 0 2e-15
C_g_M3_5_5 500_1500_M3 0 2e-15
C_g_M3_6_5 600_1500_M3 0 2e-15
C_g_M3_7_5 700_1500_M3 0 2e-15
C_g_M3_8_5 800_1500_M3 0 2e-15
C_g_M3_9_5 900_1500_M3 0 2e-15
C_g_M3_0_6 0_1600_M3 0 2e-15
C_g_M3_1_6 100_1600_M3 0 2e-15
C_g_M3_2_6 200_1600_M3 0 2e-15
C_g_M3_3_6 300_1600_M3 0 2e-15
C_g_M3_4_6 400_1600_M3 0 2e-15
C_g_M3_5_6 500_1600_M3 0 2e-15
C_g_M3_6_6 600_1600_M3 0 2e-15
C_g_M3_7_6 700_1600_M3 0 2e-15
C_g_M3_8_6 800_1600_M3 0 2e-15
C_g_M3_9_6 900_1600_M3 0 2e-15
C_g_M3_0_7 0_1700_M3 0 2e-15
C_g_M3_1_7 100_1700_M3 0 2e-15
C_g_M3_2_7 200_1700_M3 0 2e-15
C_g_M3_3_7 300_1700_M3 0 2e-15
C_g_M3_4_7 400_1700_M3 0 2e-15
C_g_M3_5_7 500_1700_M3 0 2e-15
C_g_M3_6_7 600_1700_M3 0 2e-15
C_g_M3_7_7 700_1700_M3 0 2e-15
C_g_M3_8_7 800_1700_M3 0 2e-15
C_g_M3_9_7 900_1700_M3 0 2e-15
C_g_M3_0_8 0_1800_M3 0 2e-15
C_g_M3_1_8 100_1800_M3 0 2e-15
C_g_M3_2_8 200_1800_M3 0 2e-15
C_g_M3_3_8 300_1800_M3 0 2e-15
C_g_M3_4_8 400_1800_M3 0 2e-15
C_g_M3_5_8 500_1800_M3 0 2e-15
C_g_M3_6_8 600_1800_M3 0 2e-15
C_g_M3_7_8 700_1800_M3 0 2e-15
C_g_M3_8_8 800_1800_M3 0 2e-15
C_g_M3_9_8 900_1800_M3 0 2e-15
C_g_M3_0_9 0_1900_M3 0 2e-15
C_g_M3_1_9 100_1900_M3 0 2e-15
C_g_M3_2_9 200_1900_M3 0 2e-15
C_g_M3_3_9 300_1900_M3 0 2e-15
C_g_M3_4_9 400_1900_M3 0 2e-15
C_g_M3_5_9 500_1900_M3 0 2e-15
C_g_M3_6_9 600_1900_M3 0 2e-15
C_g_M3_7_9 700_1900_M3 0 2e-15
C_g_M3_8_9 800_1900_M3 0 2e-15
C_g_M3_9_9 900_1900_M3 0 2e-15
* Coupling capacitors (C=1.0 fF)
C_coup_M3_0_0 0_1000_M3 100_1000_M3 1e-15
C_coup_M3_2_0 200_1000_M3 300_1000_M3 1e-15
C_coup_M3_4_0 400_1000_M3 500_1000_M3 1e-15
C_coup_M3_6_0 600_1000_M3 700_1000_M3 1e-15
C_coup_M3_8_0 800_1000_M3 900_1000_M3 1e-15
C_coup_M3_0_1 0_1100_M3 100_1100_M3 1e-15
C_coup_M3_2_1 200_1100_M3 300_1100_M3 1e-15
C_coup_M3_4_1 400_1100_M3 500_1100_M3 1e-15
C_coup_M3_6_1 600_1100_M3 700_1100_M3 1e-15
C_coup_M3_8_1 800_1100_M3 900_1100_M3 1e-15
C_coup_M3_0_2 0_1200_M3 100_1200_M3 1e-15
C_coup_M3_2_2 200_1200_M3 300_1200_M3 1e-15
C_coup_M3_4_2 400_1200_M3 500_1200_M3 1e-15
C_coup_M3_6_2 600_1200_M3 700_1200_M3 1e-15
C_coup_M3_8_2 800_1200_M3 900_1200_M3 1e-15
C_coup_M3_0_3 0_1300_M3 100_1300_M3 1e-15
C_coup_M3_2_3 200_1300_M3 300_1300_M3 1e-15
C_coup_M3_4_3 400_1300_M3 500_1300_M3 1e-15
C_coup_M3_6_3 600_1300_M3 700_1300_M3 1e-15
C_coup_M3_8_3 800_1300_M3 900_1300_M3 1e-15
C_coup_M3_0_4 0_1400_M3 100_1400_M3 1e-15
C_coup_M3_2_4 200_1400_M3 300_1400_M3 1e-15
C_coup_M3_4_4 400_1400_M3 500_1400_M3 1e-15
C_coup_M3_6_4 600_1400_M3 700_1400_M3 1e-15
C_coup_M3_8_4 800_1400_M3 900_1400_M3 1e-15
C_coup_M3_0_5 0_1500_M3 100_1500_M3 1e-15
C_coup_M3_2_5 200_1500_M3 300_1500_M3 1e-15
C_coup_M3_4_5 400_1500_M3 500_1500_M3 1e-15
C_coup_M3_6_5 600_1500_M3 700_1500_M3 1e-15
C_coup_M3_8_5 800_1500_M3 900_1500_M3 1e-15
C_coup_M3_0_6 0_1600_M3 100_1600_M3 1e-15
C_coup_M3_2_6 200_1600_M3 300_1600_M3 1e-15
C_coup_M3_4_6 400_1600_M3 500_1600_M3 1e-15
C_coup_M3_6_6 600_1600_M3 700_1600_M3 1e-15
C_coup_M3_8_6 800_1600_M3 900_1600_M3 1e-15
C_coup_M3_0_7 0_1700_M3 100_1700_M3 1e-15
C_coup_M3_2_7 200_1700_M3 300_1700_M3 1e-15
C_coup_M3_4_7 400_1700_M3 500_1700_M3 1e-15
C_coup_M3_6_7 600_1700_M3 700_1700_M3 1e-15
C_coup_M3_8_7 800_1700_M3 900_1700_M3 1e-15
C_coup_M3_0_8 0_1800_M3 100_1800_M3 1e-15
C_coup_M3_2_8 200_1800_M3 300_1800_M3 1e-15
C_coup_M3_4_8 400_1800_M3 500_1800_M3 1e-15
C_coup_M3_6_8 600_1800_M3 700_1800_M3 1e-15
C_coup_M3_8_8 800_1800_M3 900_1800_M3 1e-15
C_coup_M3_0_9 0_1900_M3 100_1900_M3 1e-15
C_coup_M3_2_9 200_1900_M3 300_1900_M3 1e-15
C_coup_M3_4_9 400_1900_M3 500_1900_M3 1e-15
C_coup_M3_6_9 600_1900_M3 700_1900_M3 1e-15
C_coup_M3_8_9 800_1900_M3 900_1900_M3 1e-15

* ========== Via connections ==========
* Vias M1 to M2 (R=0.5 Ohm)
R_via_M1_M2_0_0 0_1000_M1 0_1000_M2 0.5
R_via_M1_M2_2_0 200_1000_M1 200_1000_M2 0.5
R_via_M1_M2_4_0 400_1000_M1 400_1000_M2 0.5
R_via_M1_M2_6_0 600_1000_M1 600_1000_M2 0.5
R_via_M1_M2_8_0 800_1000_M1 800_1000_M2 0.5
R_via_M1_M2_0_2 0_1200_M1 0_1200_M2 0.5
R_via_M1_M2_2_2 200_1200_M1 200_1200_M2 0.5
R_via_M1_M2_4_2 400_1200_M1 400_1200_M2 0.5
R_via_M1_M2_6_2 600_1200_M1 600_1200_M2 0.5
R_via_M1_M2_8_2 800_1200_M1 800_1200_M2 0.5
R_via_M1_M2_0_4 0_1400_M1 0_1400_M2 0.5
R_via_M1_M2_2_4 200_1400_M1 200_1400_M2 0.5
R_via_M1_M2_4_4 400_1400_M1 400_1400_M2 0.5
R_via_M1_M2_6_4 600_1400_M1 600_1400_M2 0.5
R_via_M1_M2_8_4 800_1400_M1 800_1400_M2 0.5
R_via_M1_M2_0_6 0_1600_M1 0_1600_M2 0.5
R_via_M1_M2_2_6 200_1600_M1 200_1600_M2 0.5
R_via_M1_M2_4_6 400_1600_M1 400_1600_M2 0.5
R_via_M1_M2_6_6 600_1600_M1 600_1600_M2 0.5
R_via_M1_M2_8_6 800_1600_M1 800_1600_M2 0.5
R_via_M1_M2_0_8 0_1800_M1 0_1800_M2 0.5
R_via_M1_M2_2_8 200_1800_M1 200_1800_M2 0.5
R_via_M1_M2_4_8 400_1800_M1 400_1800_M2 0.5
R_via_M1_M2_6_8 600_1800_M1 600_1800_M2 0.5
R_via_M1_M2_8_8 800_1800_M1 800_1800_M2 0.5
* Vias M2 to M3 (R=0.3 Ohm)
R_via_M2_M3_0_0 0_1000_M2 0_1000_M3 0.3
R_via_M2_M3_2_0 200_1000_M2 200_1000_M3 0.3
R_via_M2_M3_4_0 400_1000_M2 400_1000_M3 0.3
R_via_M2_M3_6_0 600_1000_M2 600_1000_M3 0.3
R_via_M2_M3_8_0 800_1000_M2 800_1000_M3 0.3
R_via_M2_M3_0_2 0_1200_M2 0_1200_M3 0.3
R_via_M2_M3_2_2 200_1200_M2 200_1200_M3 0.3
R_via_M2_M3_4_2 400_1200_M2 400_1200_M3 0.3
R_via_M2_M3_6_2 600_1200_M2 600_1200_M3 0.3
R_via_M2_M3_8_2 800_1200_M2 800_1200_M3 0.3
R_via_M2_M3_0_4 0_1400_M2 0_1400_M3 0.3
R_via_M2_M3_2_4 200_1400_M2 200_1400_M3 0.3
R_via_M2_M3_4_4 400_1400_M2 400_1400_M3 0.3
R_via_M2_M3_6_4 600_1400_M2 600_1400_M3 0.3
R_via_M2_M3_8_4 800_1400_M2 800_1400_M3 0.3
R_via_M2_M3_0_6 0_1600_M2 0_1600_M3 0.3
R_via_M2_M3_2_6 200_1600_M2 200_1600_M3 0.3
R_via_M2_M3_4_6 400_1600_M2 400_1600_M3 0.3
R_via_M2_M3_6_6 600_1600_M2 600_1600_M3 0.3
R_via_M2_M3_8_6 800_1600_M2 800_1600_M3 0.3
R_via_M2_M3_0_8 0_1800_M2 0_1800_M3 0.3
R_via_M2_M3_2_8 200_1800_M2 200_1800_M3 0.3
R_via_M2_M3_4_8 400_1800_M2 400_1800_M3 0.3
R_via_M2_M3_6_8 600_1800_M2 600_1800_M3 0.3
R_via_M2_M3_8_8 800_1800_M2 800_1800_M3 0.3

* ========== Decoupling capacitors ==========
C_decap_1_1 100_1100_M1 0 2e-13
C_decap_4_1 400_1100_M1 0 5e-14
C_decap_7_1 700_1100_M1 0 2e-13
C_decap_1_4 100_1400_M1 0 5e-14
C_decap_4_4 400_1400_M1 0 2e-13
C_decap_7_4 700_1400_M1 0 5e-14
C_decap_1_7 100_1700_M1 0 2e-13
C_decap_4_7 400_1700_M1 0 5e-14
C_decap_7_7 700_1700_M1 0 2e-13
* (9 decaps placed)

* ========== Boundary connections ==========
* Right boundary to tile_1_1
R_bnd_r_M1_0 *900_1000_M1 *1000_1000_M1 8
R_bnd_r_M2_0 *900_1000_M2 *1000_1000_M2 5
R_bnd_r_M3_0 *900_1000_M3 *1000_1000_M3 3
R_bnd_r_M1_1 *900_1100_M1 *1000_1100_M1 8
R_bnd_r_M2_1 *900_1100_M2 *1000_1100_M2 5
R_bnd_r_M3_1 *900_1100_M3 *1000_1100_M3 3
R_bnd_r_M1_2 *900_1200_M1 *1000_1200_M1 8
R_bnd_r_M2_2 *900_1200_M2 *1000_1200_M2 5
R_bnd_r_M3_2 *900_1200_M3 *1000_1200_M3 3
R_bnd_r_M1_3 *900_1300_M1 *1000_1300_M1 8
R_bnd_r_M2_3 *900_1300_M2 *1000_1300_M2 5
R_bnd_r_M3_3 *900_1300_M3 *1000_1300_M3 3
R_bnd_r_M1_4 *900_1400_M1 *1000_1400_M1 8
R_bnd_r_M2_4 *900_1400_M2 *1000_1400_M2 5
R_bnd_r_M3_4 *900_1400_M3 *1000_1400_M3 3
R_bnd_r_M1_5 *900_1500_M1 *1000_1500_M1 8
R_bnd_r_M2_5 *900_1500_M2 *1000_1500_M2 5
R_bnd_r_M3_5 *900_1500_M3 *1000_1500_M3 3
R_bnd_r_M1_6 *900_1600_M1 *1000_1600_M1 8
R_bnd_r_M2_6 *900_1600_M2 *1000_1600_M2 5
R_bnd_r_M3_6 *900_1600_M3 *1000_1600_M3 3
R_bnd_r_M1_7 *900_1700_M1 *1000_1700_M1 8
R_bnd_r_M2_7 *900_1700_M2 *1000_1700_M2 5
R_bnd_r_M3_7 *900_1700_M3 *1000_1700_M3 3
R_bnd_r_M1_8 *900_1800_M1 *1000_1800_M1 8
R_bnd_r_M2_8 *900_1800_M2 *1000_1800_M2 5
R_bnd_r_M3_8 *900_1800_M3 *1000_1800_M3 3
R_bnd_r_M1_9 *900_1900_M1 *1000_1900_M1 8
R_bnd_r_M2_9 *900_1900_M2 *1000_1900_M2 5
R_bnd_r_M3_9 *900_1900_M3 *1000_1900_M3 3
* Top boundary to tile_0_2
R_bnd_t_M1_0 *0_1900_M1 *0_2000_M1 10
R_bnd_t_M2_0 *0_1900_M2 *0_2000_M2 6
R_bnd_t_M3_0 *0_1900_M3 *0_2000_M3 4
R_bnd_t_M1_1 *100_1900_M1 *100_2000_M1 10
R_bnd_t_M2_1 *100_1900_M2 *100_2000_M2 6
R_bnd_t_M3_1 *100_1900_M3 *100_2000_M3 4
R_bnd_t_M1_2 *200_1900_M1 *200_2000_M1 10
R_bnd_t_M2_2 *200_1900_M2 *200_2000_M2 6
R_bnd_t_M3_2 *200_1900_M3 *200_2000_M3 4
R_bnd_t_M1_3 *300_1900_M1 *300_2000_M1 10
R_bnd_t_M2_3 *300_1900_M2 *300_2000_M2 6
R_bnd_t_M3_3 *300_1900_M3 *300_2000_M3 4
R_bnd_t_M1_4 *400_1900_M1 *400_2000_M1 10
R_bnd_t_M2_4 *400_1900_M2 *400_2000_M2 6
R_bnd_t_M3_4 *400_1900_M3 *400_2000_M3 4
R_bnd_t_M1_5 *500_1900_M1 *500_2000_M1 10
R_bnd_t_M2_5 *500_1900_M2 *500_2000_M2 6
R_bnd_t_M3_5 *500_1900_M3 *500_2000_M3 4
R_bnd_t_M1_6 *600_1900_M1 *600_2000_M1 10
R_bnd_t_M2_6 *600_1900_M2 *600_2000_M2 6
R_bnd_t_M3_6 *600_1900_M3 *600_2000_M3 4
R_bnd_t_M1_7 *700_1900_M1 *700_2000_M1 10
R_bnd_t_M2_7 *700_1900_M2 *700_2000_M2 6
R_bnd_t_M3_7 *700_1900_M3 *700_2000_M3 4
R_bnd_t_M1_8 *800_1900_M1 *800_2000_M1 10
R_bnd_t_M2_8 *800_1900_M2 *800_2000_M2 6
R_bnd_t_M3_8 *800_1900_M3 *800_2000_M3 4
R_bnd_t_M1_9 *900_1900_M1 *900_2000_M1 10
R_bnd_t_M2_9 *900_1900_M2 *900_2000_M2 6
R_bnd_t_M3_9 *900_1900_M3 *900_2000_M3 4

* Tile 0_1 summary: 650 R, 459 C
